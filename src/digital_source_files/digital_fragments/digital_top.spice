* NGSPICE file created from digital_top.ext - technology: sky130A

* Black-box entry subcircuit for sky130_fd_sc_hd__fill_1 abstract view
.subckt sky130_fd_sc_hd__fill_1 VGND VNB VPB VPWR
.ends

* Black-box entry subcircuit for sky130_fd_sc_hd__dfrtp_1 abstract view
.subckt sky130_fd_sc_hd__dfrtp_1 CLK D RESET_B VGND VNB VPB VPWR Q
.ends

* Black-box entry subcircuit for sky130_fd_sc_hd__dfstp_2 abstract view
.subckt sky130_fd_sc_hd__dfstp_2 CLK D SET_B VGND VNB VPB VPWR Q
.ends

* Black-box entry subcircuit for sky130_fd_sc_hd__decap_3 abstract view
.subckt sky130_fd_sc_hd__decap_3 VGND VNB VPB VPWR
.ends

* Black-box entry subcircuit for sky130_fd_sc_hd__tapvpwrvgnd_1 abstract view
.subckt sky130_fd_sc_hd__tapvpwrvgnd_1 VGND VPWR
.ends

* Black-box entry subcircuit for sky130_fd_sc_hd__clkbuf_4 abstract view
.subckt sky130_fd_sc_hd__clkbuf_4 A VGND VNB VPB VPWR X
.ends

* Black-box entry subcircuit for sky130_fd_sc_hd__o21ai_0 abstract view
.subckt sky130_fd_sc_hd__o21ai_0 A1 A2 B1 VGND VNB VPB VPWR Y
.ends

* Black-box entry subcircuit for sky130_fd_sc_hd__a211o_1 abstract view
.subckt sky130_fd_sc_hd__a211o_1 A1 A2 B1 C1 VGND VNB VPB VPWR X
.ends

* Black-box entry subcircuit for sky130_fd_sc_hd__nor2b_1 abstract view
.subckt sky130_fd_sc_hd__nor2b_1 A B_N VGND VNB VPB VPWR Y
.ends

* Black-box entry subcircuit for sky130_fd_sc_hd__clkdlybuf4s50_1 abstract view
.subckt sky130_fd_sc_hd__clkdlybuf4s50_1 A VGND VNB VPB VPWR X
.ends

* Black-box entry subcircuit for sky130_fd_sc_hd__a21oi_1 abstract view
.subckt sky130_fd_sc_hd__a21oi_1 A1 A2 B1 VGND VNB VPB VPWR Y
.ends

* Black-box entry subcircuit for sky130_fd_sc_hd__mux2_1 abstract view
.subckt sky130_fd_sc_hd__mux2_1 A0 A1 S VGND VNB VPB VPWR X
.ends

* Black-box entry subcircuit for sky130_fd_sc_hd__xor2_1 abstract view
.subckt sky130_fd_sc_hd__xor2_1 A B VGND VNB VPB VPWR X
.ends

* Black-box entry subcircuit for sky130_fd_sc_hd__fill_2 abstract view
.subckt sky130_fd_sc_hd__fill_2 VGND VNB VPB VPWR
.ends

* Black-box entry subcircuit for sky130_fd_sc_hd__xnor3_1 abstract view
.subckt sky130_fd_sc_hd__xnor3_1 A B C VGND VNB VPB VPWR X
.ends

* Black-box entry subcircuit for sky130_fd_sc_hd__nor2_1 abstract view
.subckt sky130_fd_sc_hd__nor2_1 A B VGND VNB VPB VPWR Y
.ends

* Black-box entry subcircuit for sky130_fd_sc_hd__clkbuf_16 abstract view
.subckt sky130_fd_sc_hd__clkbuf_16 A VGND VNB VPB VPWR X
.ends

* Black-box entry subcircuit for sky130_fd_sc_hd__decap_6 abstract view
.subckt sky130_fd_sc_hd__decap_6 VGND VNB VPB VPWR
.ends

* Black-box entry subcircuit for sky130_fd_sc_hd__edfxtp_1 abstract view
.subckt sky130_fd_sc_hd__edfxtp_1 CLK D DE VGND VNB VPB VPWR Q
.ends

* Black-box entry subcircuit for sky130_fd_sc_hd__o21a_1 abstract view
.subckt sky130_fd_sc_hd__o21a_1 A1 A2 B1 VGND VNB VPB VPWR X
.ends

* Black-box entry subcircuit for sky130_fd_sc_hd__o2bb2ai_1 abstract view
.subckt sky130_fd_sc_hd__o2bb2ai_1 A1_N A2_N B1 B2 VGND VNB VPB VPWR Y
.ends

* Black-box entry subcircuit for sky130_fd_sc_hd__decap_12 abstract view
.subckt sky130_fd_sc_hd__decap_12 VGND VNB VPB VPWR
.ends

* Black-box entry subcircuit for sky130_fd_sc_hd__clkbuf_2 abstract view
.subckt sky130_fd_sc_hd__clkbuf_2 A VGND VNB VPB VPWR X
.ends

* Black-box entry subcircuit for sky130_fd_sc_hd__nor3_1 abstract view
.subckt sky130_fd_sc_hd__nor3_1 A B C VGND VNB VPB VPWR Y
.ends

* Black-box entry subcircuit for sky130_fd_sc_hd__dfxtp_1 abstract view
.subckt sky130_fd_sc_hd__dfxtp_1 CLK D VGND VNB VPB VPWR Q
.ends

* Black-box entry subcircuit for sky130_fd_sc_hd__conb_1 abstract view
.subckt sky130_fd_sc_hd__conb_1 VGND VNB VPB VPWR HI LO
.ends

* Black-box entry subcircuit for sky130_fd_sc_hd__o21ba_1 abstract view
.subckt sky130_fd_sc_hd__o21ba_1 A1 A2 B1_N VGND VNB VPB VPWR X
.ends

* Black-box entry subcircuit for sky130_fd_sc_hd__decap_4 abstract view
.subckt sky130_fd_sc_hd__decap_4 VGND VNB VPB VPWR
.ends

* Black-box entry subcircuit for sky130_fd_sc_hd__mux2i_1 abstract view
.subckt sky130_fd_sc_hd__mux2i_1 A0 A1 S VGND VNB VPB VPWR Y
.ends

* Black-box entry subcircuit for sky130_fd_sc_hd__and2_0 abstract view
.subckt sky130_fd_sc_hd__and2_0 A B VGND VNB VPB VPWR X
.ends

* Black-box entry subcircuit for sky130_fd_sc_hd__xor3_1 abstract view
.subckt sky130_fd_sc_hd__xor3_1 A B C VGND VNB VPB VPWR X
.ends

* Black-box entry subcircuit for sky130_fd_sc_hd__o211ai_1 abstract view
.subckt sky130_fd_sc_hd__o211ai_1 A1 A2 B1 C1 VGND VNB VPB VPWR Y
.ends

* Black-box entry subcircuit for sky130_fd_sc_hd__o2111ai_1 abstract view
.subckt sky130_fd_sc_hd__o2111ai_1 A1 A2 B1 C1 D1 VGND VNB VPB VPWR Y
.ends

* Black-box entry subcircuit for sky130_fd_sc_hd__nand2_1 abstract view
.subckt sky130_fd_sc_hd__nand2_1 A B VGND VNB VPB VPWR Y
.ends

* Black-box entry subcircuit for sky130_fd_sc_hd__o32a_1 abstract view
.subckt sky130_fd_sc_hd__o32a_1 A1 A2 A3 B1 B2 VGND VNB VPB VPWR X
.ends

* Black-box entry subcircuit for sky130_fd_sc_hd__inv_1 abstract view
.subckt sky130_fd_sc_hd__inv_1 A VGND VNB VPB VPWR Y
.ends

* Black-box entry subcircuit for sky130_fd_sc_hd__buf_4 abstract view
.subckt sky130_fd_sc_hd__buf_4 A VGND VNB VPB VPWR X
.ends

* Black-box entry subcircuit for sky130_fd_sc_hd__nor4b_2 abstract view
.subckt sky130_fd_sc_hd__nor4b_2 A B C D_N VGND VNB VPB VPWR Y
.ends

* Black-box entry subcircuit for sky130_fd_sc_hd__decap_8 abstract view
.subckt sky130_fd_sc_hd__decap_8 VGND VNB VPB VPWR
.ends

* Black-box entry subcircuit for sky130_fd_sc_hd__nor3b_1 abstract view
.subckt sky130_fd_sc_hd__nor3b_1 A B C_N VGND VNB VPB VPWR Y
.ends

* Black-box entry subcircuit for sky130_fd_sc_hd__o31ai_1 abstract view
.subckt sky130_fd_sc_hd__o31ai_1 A1 A2 A3 B1 VGND VNB VPB VPWR Y
.ends

* Black-box entry subcircuit for sky130_fd_sc_hd__o21bai_1 abstract view
.subckt sky130_fd_sc_hd__o21bai_1 A1 A2 B1_N VGND VNB VPB VPWR Y
.ends

* Black-box entry subcircuit for sky130_fd_sc_hd__and3_1 abstract view
.subckt sky130_fd_sc_hd__and3_1 A B C VGND VNB VPB VPWR X
.ends

* Black-box entry subcircuit for sky130_fd_sc_hd__o221a_1 abstract view
.subckt sky130_fd_sc_hd__o221a_1 A1 A2 B1 B2 C1 VGND VNB VPB VPWR X
.ends

* Black-box entry subcircuit for sky130_fd_sc_hd__a21o_1 abstract view
.subckt sky130_fd_sc_hd__a21o_1 A1 A2 B1 VGND VNB VPB VPWR X
.ends

* Black-box entry subcircuit for sky130_fd_sc_hd__buf_2 abstract view
.subckt sky130_fd_sc_hd__buf_2 A VGND VNB VPB VPWR X
.ends

* Black-box entry subcircuit for sky130_fd_sc_hd__nand2b_1 abstract view
.subckt sky130_fd_sc_hd__nand2b_1 A_N B VGND VNB VPB VPWR Y
.ends

* Black-box entry subcircuit for sky130_fd_sc_hd__a31oi_1 abstract view
.subckt sky130_fd_sc_hd__a31oi_1 A1 A2 A3 B1 VGND VNB VPB VPWR Y
.ends

* Black-box entry subcircuit for sky130_fd_sc_hd__a2bb2oi_1 abstract view
.subckt sky130_fd_sc_hd__a2bb2oi_1 A1_N A2_N B1 B2 VGND VNB VPB VPWR Y
.ends

* Black-box entry subcircuit for sky130_fd_sc_hd__o31a_1 abstract view
.subckt sky130_fd_sc_hd__o31a_1 A1 A2 A3 B1 VGND VNB VPB VPWR X
.ends

* Black-box entry subcircuit for sky130_fd_sc_hd__o22ai_1 abstract view
.subckt sky130_fd_sc_hd__o22ai_1 A1 A2 B1 B2 VGND VNB VPB VPWR Y
.ends

* Black-box entry subcircuit for sky130_fd_sc_hd__or3_1 abstract view
.subckt sky130_fd_sc_hd__or3_1 A B C VGND VNB VPB VPWR X
.ends

* Black-box entry subcircuit for sky130_fd_sc_hd__clkbuf_1 abstract view
.subckt sky130_fd_sc_hd__clkbuf_1 A VGND VNB VPB VPWR X
.ends

* Black-box entry subcircuit for sky130_fd_sc_hd__nand3_1 abstract view
.subckt sky130_fd_sc_hd__nand3_1 A B C VGND VNB VPB VPWR Y
.ends

* Black-box entry subcircuit for sky130_fd_sc_hd__clkinv_2 abstract view
.subckt sky130_fd_sc_hd__clkinv_2 A VGND VNB VPB VPWR Y
.ends

* Black-box entry subcircuit for sky130_fd_sc_hd__a222oi_1 abstract view
.subckt sky130_fd_sc_hd__a222oi_1 A1 A2 B1 B2 C1 C2 VGND VNB VPB VPWR Y
.ends

* Black-box entry subcircuit for sky130_fd_sc_hd__a22oi_1 abstract view
.subckt sky130_fd_sc_hd__a22oi_1 A1 A2 B1 B2 VGND VNB VPB VPWR Y
.ends

* Black-box entry subcircuit for sky130_fd_sc_hd__clkbuf_8 abstract view
.subckt sky130_fd_sc_hd__clkbuf_8 A VGND VNB VPB VPWR X
.ends

* Black-box entry subcircuit for sky130_fd_sc_hd__nand4_1 abstract view
.subckt sky130_fd_sc_hd__nand4_1 A B C D VGND VNB VPB VPWR Y
.ends

* Black-box entry subcircuit for sky130_fd_sc_hd__nor4_1 abstract view
.subckt sky130_fd_sc_hd__nor4_1 A B C D VGND VNB VPB VPWR Y
.ends

* Black-box entry subcircuit for sky130_fd_sc_hd__inv_6 abstract view
.subckt sky130_fd_sc_hd__inv_6 A VGND VNB VPB VPWR Y
.ends

* Black-box entry subcircuit for sky130_fd_sc_hd__xnor2_1 abstract view
.subckt sky130_fd_sc_hd__xnor2_1 A B VGND VNB VPB VPWR Y
.ends

* Black-box entry subcircuit for sky130_fd_sc_hd__nor3_2 abstract view
.subckt sky130_fd_sc_hd__nor3_2 A B C VGND VNB VPB VPWR Y
.ends

* Black-box entry subcircuit for sky130_fd_sc_hd__buf_1 abstract view
.subckt sky130_fd_sc_hd__buf_1 A VGND VNB VPB VPWR X
.ends

* Black-box entry subcircuit for sky130_fd_sc_hd__nor3b_2 abstract view
.subckt sky130_fd_sc_hd__nor3b_2 A B C_N VGND VNB VPB VPWR Y
.ends

* Black-box entry subcircuit for sky130_fd_sc_hd__a31o_1 abstract view
.subckt sky130_fd_sc_hd__a31o_1 A1 A2 A3 B1 VGND VNB VPB VPWR X
.ends

* Black-box entry subcircuit for sky130_fd_sc_hd__a221oi_1 abstract view
.subckt sky130_fd_sc_hd__a221oi_1 A1 A2 B1 B2 C1 VGND VNB VPB VPWR Y
.ends

* Black-box entry subcircuit for sky130_fd_sc_hd__a41oi_1 abstract view
.subckt sky130_fd_sc_hd__a41oi_1 A1 A2 A3 A4 B1 VGND VNB VPB VPWR Y
.ends

* Black-box entry subcircuit for sky130_fd_sc_hd__o211a_1 abstract view
.subckt sky130_fd_sc_hd__o211a_1 A1 A2 B1 C1 VGND VNB VPB VPWR X
.ends

* Black-box entry subcircuit for sky130_fd_sc_hd__a32o_1 abstract view
.subckt sky130_fd_sc_hd__a32o_1 A1 A2 A3 B1 B2 VGND VNB VPB VPWR X
.ends

* Black-box entry subcircuit for sky130_fd_sc_hd__dlygate4sd3_1 abstract view
.subckt sky130_fd_sc_hd__dlygate4sd3_1 A VGND VNB VPB VPWR X
.ends

* Black-box entry subcircuit for sky130_fd_sc_hd__a21boi_0 abstract view
.subckt sky130_fd_sc_hd__a21boi_0 A1 A2 B1_N VGND VNB VPB VPWR Y
.ends

* Black-box entry subcircuit for sky130_fd_sc_hd__nor4_2 abstract view
.subckt sky130_fd_sc_hd__nor4_2 A B C D VGND VNB VPB VPWR Y
.ends

* Black-box entry subcircuit for sky130_fd_sc_hd__o311ai_0 abstract view
.subckt sky130_fd_sc_hd__o311ai_0 A1 A2 A3 B1 C1 VGND VNB VPB VPWR Y
.ends

* Black-box entry subcircuit for sky130_fd_sc_hd__clkdlybuf4s25_1 abstract view
.subckt sky130_fd_sc_hd__clkdlybuf4s25_1 A VGND VNB VPB VPWR X
.ends

* Black-box entry subcircuit for sky130_fd_sc_hd__nand3b_1 abstract view
.subckt sky130_fd_sc_hd__nand3b_1 A_N B C VGND VNB VPB VPWR Y
.ends

* Black-box entry subcircuit for sky130_fd_sc_hd__nand4b_1 abstract view
.subckt sky130_fd_sc_hd__nand4b_1 A_N B C D VGND VNB VPB VPWR Y
.ends

* Black-box entry subcircuit for sky130_fd_sc_hd__or2_0 abstract view
.subckt sky130_fd_sc_hd__or2_0 A B VGND VNB VPB VPWR X
.ends

* Black-box entry subcircuit for sky130_fd_sc_hd__and4b_1 abstract view
.subckt sky130_fd_sc_hd__and4b_1 A_N B C D VGND VNB VPB VPWR X
.ends

* Black-box entry subcircuit for sky130_fd_sc_hd__ebufn_2 abstract view
.subckt sky130_fd_sc_hd__ebufn_2 A TE_B VGND VNB VPB VPWR Z
.ends

* Black-box entry subcircuit for sky130_fd_sc_hd__or4b_1 abstract view
.subckt sky130_fd_sc_hd__or4b_1 A B C D_N VGND VNB VPB VPWR X
.ends

* Black-box entry subcircuit for sky130_fd_sc_hd__nor4bb_4 abstract view
.subckt sky130_fd_sc_hd__nor4bb_4 A B C_N D_N VGND VNB VPB VPWR Y
.ends

* Black-box entry subcircuit for sky130_fd_sc_hd__o41ai_1 abstract view
.subckt sky130_fd_sc_hd__o41ai_1 A1 A2 A3 A4 B1 VGND VNB VPB VPWR Y
.ends

* Black-box entry subcircuit for sky130_fd_sc_hd__diode_2 abstract view
.subckt sky130_fd_sc_hd__diode_2 DIODE VGND VNB VPB VPWR
.ends

* Black-box entry subcircuit for sky130_fd_sc_hd__o311a_1 abstract view
.subckt sky130_fd_sc_hd__o311a_1 A1 A2 A3 B1 C1 VGND VNB VPB VPWR X
.ends

* Black-box entry subcircuit for sky130_fd_sc_hd__and3b_1 abstract view
.subckt sky130_fd_sc_hd__and3b_1 A_N B C VGND VNB VPB VPWR X
.ends

* Black-box entry subcircuit for sky130_fd_sc_hd__a22o_1 abstract view
.subckt sky130_fd_sc_hd__a22o_1 A1 A2 B1 B2 VGND VNB VPB VPWR X
.ends

* Black-box entry subcircuit for sky130_fd_sc_hd__o21ai_1 abstract view
.subckt sky130_fd_sc_hd__o21ai_1 A1 A2 B1 VGND VNB VPB VPWR Y
.ends

.subckt digital_top VGND VPWR dclk dena drst_n dui_in[0] dui_in[1] dui_in[2] dui_in[3]
+ dui_in[4] dui_in[5] dui_in[6] dui_in[7] duio_in[0] duio_in[1] duio_in[2] duio_in[3]
+ duio_in[4] duio_in[5] duio_in[6] duio_in[7] duio_oe[0] duio_oe[1] duio_oe[2] duio_oe[3]
+ duio_oe[4] duio_oe[5] duio_oe[6] duio_oe[7] duio_out[0] duio_out[1] duio_out[2]
+ duio_out[3] duio_out[4] duio_out[5] duio_out[6] duio_out[7] duo_out[0] duo_out[1]
+ duo_out[2] duo_out[3] duo_out[4] duo_out[5] duo_out[6] duo_out[7]
XFILLER_36_19 VGND VGND VPWR VPWR sky130_fd_sc_hd__fill_1
X_2106_ clkload7/A _2106_/D _2145_/SET_B VGND VGND VPWR VPWR _2106_/Q sky130_fd_sc_hd__dfrtp_1
X_2037_ _2230_/CLK _2037_/D _2058_/SET_B VGND VGND VPWR VPWR _2037_/Q sky130_fd_sc_hd__dfstp_2
XFILLER_26_85 VGND VGND VPWR VPWR sky130_fd_sc_hd__fill_1
XFILLER_45_225 VGND VGND VPWR VPWR sky130_fd_sc_hd__decap_3
XFILLER_60_206 VGND VGND VPWR VPWR sky130_fd_sc_hd__fill_1
XTAP_TAPCELL_ROW_8_170 VGND VPWR sky130_fd_sc_hd__tapvpwrvgnd_1
Xwire29 wire29/A VGND VGND VPWR VPWR wire29/X sky130_fd_sc_hd__clkbuf_4
X_1270_ _1210_/A _2203_/Q _1270_/B1 VGND VGND VPWR VPWR _1270_/Y sky130_fd_sc_hd__o21ai_0
XFILLER_51_239 VGND VGND VPWR VPWR sky130_fd_sc_hd__fill_1
X_0985_ _2142_/Q wire52/X _1661_/B1 _0963_/Y VGND VGND VPWR VPWR _0985_/X sky130_fd_sc_hd__a211o_1
X_1606_ _1938_/Q _1605_/A VGND VGND VPWR VPWR _1607_/A sky130_fd_sc_hd__nor2b_1
Xfanout116 _1456_/A2 VGND VGND VPWR VPWR _1451_/B2 sky130_fd_sc_hd__clkdlybuf4s50_1
Xfanout127 _1287_/A2 VGND VGND VPWR VPWR _1282_/A2 sky130_fd_sc_hd__clkdlybuf4s50_1
Xfanout138 _1327_/B1 VGND VGND VPWR VPWR _1300_/B1 sky130_fd_sc_hd__clkdlybuf4s50_1
Xfanout149 _1604_/A VGND VGND VPWR VPWR _1609_/A sky130_fd_sc_hd__clkdlybuf4s50_1
X_1537_ _1610_/A _1394_/X _1536_/Y VGND VGND VPWR VPWR _1537_/Y sky130_fd_sc_hd__a21oi_1
X_1468_ _2123_/Q hold274/X _1885_/S VGND VGND VPWR VPWR _2123_/D sky130_fd_sc_hd__mux2_1
X_1399_ _1938_/Q _1956_/Q VGND VGND VPWR VPWR _1400_/C sky130_fd_sc_hd__xor2_1
XFILLER_10_125 VGND VGND VPWR VPWR sky130_fd_sc_hd__fill_2
XFILLER_6_118 VGND VGND VPWR VPWR sky130_fd_sc_hd__fill_2
XFILLER_18_258 VGND VGND VPWR VPWR sky130_fd_sc_hd__fill_1
XTAP_TAPCELL_ROW_11_186 VGND VPWR sky130_fd_sc_hd__tapvpwrvgnd_1
X_1322_ _1321_/B _1321_/A _1331_/S VGND VGND VPWR VPWR _1322_/Y sky130_fd_sc_hd__o21ai_0
X_1253_ _2168_/Q _1253_/B _1259_/B VGND VGND VPWR VPWR _1253_/X sky130_fd_sc_hd__xnor3_1
XFILLER_24_239 VGND VGND VPWR VPWR sky130_fd_sc_hd__fill_1
X_1184_ _1410_/S _2179_/Q _1659_/C1 VGND VGND VPWR VPWR _1184_/Y sky130_fd_sc_hd__o21ai_0
XFILLER_32_250 VGND VGND VPWR VPWR sky130_fd_sc_hd__fill_2
X_0968_ _0968_/A _0972_/A VGND VGND VPWR VPWR _1721_/C sky130_fd_sc_hd__nor2_1
XFILLER_59_169 VGND VGND VPWR VPWR sky130_fd_sc_hd__fill_1
XTAP_TAPCELL_ROW_2_143 VGND VPWR sky130_fd_sc_hd__tapvpwrvgnd_1
Xclkbuf_leaf_1_dclk clkbuf_leaf_2_dclk/A VGND VGND VPWR VPWR clkload1/A sky130_fd_sc_hd__clkbuf_16
XTAP_TAPCELL_ROW_25_256 VGND VPWR sky130_fd_sc_hd__tapvpwrvgnd_1
XFILLER_23_64 VGND VGND VPWR VPWR sky130_fd_sc_hd__fill_1
XFILLER_2_154 VGND VGND VPWR VPWR sky130_fd_sc_hd__fill_2
XFILLER_0_57 VGND VGND VPWR VPWR sky130_fd_sc_hd__decap_6
XTAP_TAPCELL_ROW_16_212 VGND VPWR sky130_fd_sc_hd__tapvpwrvgnd_1
X_1940_ clkload6/A _1940_/D _1958_/DE VGND VGND VPWR VPWR _1940_/Q sky130_fd_sc_hd__edfxtp_1
X_1871_ _2098_/Q hold285/X _1887_/S VGND VGND VPWR VPWR _2098_/D sky130_fd_sc_hd__mux2_1
XFILLER_56_139 VGND VGND VPWR VPWR sky130_fd_sc_hd__fill_1
XTAP_TAPCELL_ROW_39_326 VGND VPWR sky130_fd_sc_hd__tapvpwrvgnd_1
X_1305_ _1416_/S _2210_/Q _1450_/A3 VGND VGND VPWR VPWR _1305_/Y sky130_fd_sc_hd__o21ai_0
X_1236_ _2019_/Q _1659_/C1 _1235_/X VGND VGND VPWR VPWR _2212_/D sky130_fd_sc_hd__o21a_1
X_1167_ hold266/X _1282_/A2 _1165_/Y _1166_/Y VGND VGND VPWR VPWR _2221_/D sky130_fd_sc_hd__o2bb2ai_1
X_1098_ _1459_/B _1604_/B _2044_/Q VGND VGND VPWR VPWR _1098_/Y sky130_fd_sc_hd__o21ai_0
XFILLER_20_231 VGND VGND VPWR VPWR sky130_fd_sc_hd__fill_1
XFILLER_20_253 VGND VGND VPWR VPWR sky130_fd_sc_hd__decap_3
XTAP_TAPCELL_ROW_30_281 VGND VPWR sky130_fd_sc_hd__tapvpwrvgnd_1
XFILLER_11_253 VGND VGND VPWR VPWR sky130_fd_sc_hd__decap_12
XTAP_TAPCELL_ROW_53_395 VGND VPWR sky130_fd_sc_hd__tapvpwrvgnd_1
Xwire111 _1356_/Y VGND VGND VPWR VPWR _1358_/B sky130_fd_sc_hd__clkbuf_2
XFILLER_7_279 VGND VGND VPWR VPWR sky130_fd_sc_hd__fill_1
Xload_slew105 _1880_/S VGND VGND VPWR VPWR _1885_/S sky130_fd_sc_hd__clkbuf_4
X_2070_ clkload2/A _2070_/D fanout71/X VGND VGND VPWR VPWR _2070_/Q sky130_fd_sc_hd__dfrtp_1
XTAP_TAPCELL_ROW_44_351 VGND VPWR sky130_fd_sc_hd__tapvpwrvgnd_1
X_1021_ _1021_/A _1658_/A _1021_/C VGND VGND VPWR VPWR _1025_/C sky130_fd_sc_hd__nor3_1
X_1923_ clkload4/A _1923_/D VGND VGND VPWR VPWR _1923_/Q sky130_fd_sc_hd__dfxtp_1
X_1854_ _0969_/B _2082_/Q _1856_/S VGND VGND VPWR VPWR _2082_/D sky130_fd_sc_hd__mux2_1
X_1785_ _2023_/Q _1718_/D wire35/X VGND VGND VPWR VPWR _2023_/D sky130_fd_sc_hd__mux2_1
Xfanout7 _1714_/Y VGND VGND VPWR VPWR _1749_/B sky130_fd_sc_hd__clkdlybuf4s50_1
X_2199_ clkload3/A _2199_/D VGND VGND VPWR VPWR _2199_/Q sky130_fd_sc_hd__dfxtp_1
X_1219_ _1374_/S _2223_/Q VGND VGND VPWR VPWR _1219_/Y sky130_fd_sc_hd__nor2b_1
XFILLER_37_194 VGND VGND VPWR VPWR sky130_fd_sc_hd__fill_1
XTAP_TAPCELL_ROW_58_421 VGND VPWR sky130_fd_sc_hd__tapvpwrvgnd_1
Xdigital_top_224 VGND VGND VPWR VPWR digital_top_224/HI duio_out[1] sky130_fd_sc_hd__conb_1
Xdigital_top_235 VGND VGND VPWR VPWR digital_top_235/HI duo_out[5] sky130_fd_sc_hd__conb_1
XFILLER_6_89 VGND VGND VPWR VPWR sky130_fd_sc_hd__fill_1
X_1570_ _1610_/A _1346_/X VGND VGND VPWR VPWR _1572_/C sky130_fd_sc_hd__nor2b_1
XFILLER_13_3 VGND VGND VPWR VPWR sky130_fd_sc_hd__fill_2
X_2122_ clkload6/A _2122_/D load_slew58/X VGND VGND VPWR VPWR _2122_/Q sky130_fd_sc_hd__dfrtp_1
X_2053_ _2224_/CLK _2053_/D fanout88/X VGND VGND VPWR VPWR _2053_/Q sky130_fd_sc_hd__dfrtp_1
X_1004_ _0961_/Y _1024_/A2 _0999_/Y VGND VGND VPWR VPWR _1014_/B sky130_fd_sc_hd__a21oi_1
X_1906_ clkload8/A _1906_/D VGND VGND VPWR VPWR _1906_/Q sky130_fd_sc_hd__dfxtp_1
X_1837_ _0969_/A _2067_/Q wire29/X VGND VGND VPWR VPWR _2067_/D sky130_fd_sc_hd__mux2_1
X_1768_ _1816_/A0 _2009_/Q wire38/X VGND VGND VPWR VPWR _2009_/D sky130_fd_sc_hd__mux2_1
XFILLER_57_234 VGND VGND VPWR VPWR sky130_fd_sc_hd__fill_1
X_1699_ _2154_/Q _0996_/D _2139_/Q VGND VGND VPWR VPWR _1699_/X sky130_fd_sc_hd__o21ba_1
XFILLER_48_201 VGND VGND VPWR VPWR sky130_fd_sc_hd__fill_1
XFILLER_16_197 VGND VGND VPWR VPWR sky130_fd_sc_hd__fill_2
XFILLER_31_167 VGND VGND VPWR VPWR sky130_fd_sc_hd__fill_1
XTAP_TAPCELL_ROW_61_438 VGND VPWR sky130_fd_sc_hd__tapvpwrvgnd_1
X_1622_ _1622_/A _1632_/B _1622_/C VGND VGND VPWR VPWR _1622_/Y sky130_fd_sc_hd__nor3_1
XFILLER_39_234 VGND VGND VPWR VPWR sky130_fd_sc_hd__decap_4
X_1553_ _1630_/A _1418_/X _1552_/Y VGND VGND VPWR VPWR _1553_/Y sky130_fd_sc_hd__a21oi_1
X_1484_ _0968_/A _2131_/Q _1490_/S VGND VGND VPWR VPWR _2131_/D sky130_fd_sc_hd__mux2_1
X_2105_ clkload7/A _2105_/D _2145_/SET_B VGND VGND VPWR VPWR _2105_/Q sky130_fd_sc_hd__dfrtp_1
X_2036_ _2230_/CLK _2036_/D fanout64/X VGND VGND VPWR VPWR _2036_/Q sky130_fd_sc_hd__dfrtp_1
XFILLER_22_112 VGND VGND VPWR VPWR sky130_fd_sc_hd__decap_3
XFILLER_42_41 VGND VGND VPWR VPWR sky130_fd_sc_hd__fill_1
XFILLER_42_85 VGND VGND VPWR VPWR sky130_fd_sc_hd__fill_1
XTAP_TAPCELL_ROW_8_171 VGND VPWR sky130_fd_sc_hd__tapvpwrvgnd_1
XFILLER_51_218 VGND VGND VPWR VPWR sky130_fd_sc_hd__fill_2
X_0984_ wire52/X _0983_/Y _1456_/A2 VGND VGND VPWR VPWR _2142_/D sky130_fd_sc_hd__o21ai_0
X_1605_ _1605_/A _1388_/X VGND VGND VPWR VPWR _1607_/C sky130_fd_sc_hd__nor2b_1
X_1536_ _1610_/A _1939_/Q _1556_/B1 VGND VGND VPWR VPWR _1536_/Y sky130_fd_sc_hd__o21ai_0
Xfanout106 _1884_/S VGND VGND VPWR VPWR _1463_/S sky130_fd_sc_hd__clkdlybuf4s50_1
Xfanout117 _0979_/Y VGND VGND VPWR VPWR _1456_/A2 sky130_fd_sc_hd__clkdlybuf4s50_1
Xfanout128 _1287_/A2 VGND VGND VPWR VPWR _1267_/A2 sky130_fd_sc_hd__clkdlybuf4s50_1
Xfanout139 _1327_/B1 VGND VGND VPWR VPWR _1285_/B1 sky130_fd_sc_hd__clkdlybuf4s50_1
X_1467_ _2122_/Q hold280/X _1885_/S VGND VGND VPWR VPWR _2122_/D sky130_fd_sc_hd__mux2_1
X_1398_ _2194_/Q _2178_/Q _1416_/S VGND VGND VPWR VPWR _1400_/B sky130_fd_sc_hd__mux2i_1
XFILLER_27_259 VGND VGND VPWR VPWR sky130_fd_sc_hd__fill_2
XFILLER_35_281 VGND VGND VPWR VPWR sky130_fd_sc_hd__decap_4
XFILLER_50_251 VGND VGND VPWR VPWR sky130_fd_sc_hd__fill_1
X_2019_ clkload4/A _2019_/D wire68/X VGND VGND VPWR VPWR _2019_/Q sky130_fd_sc_hd__dfstp_2
XTAP_TAPCELL_ROW_11_187 VGND VPWR sky130_fd_sc_hd__tapvpwrvgnd_1
X_1321_ _1321_/A _1321_/B VGND VGND VPWR VPWR _1321_/X sky130_fd_sc_hd__and2_0
X_1252_ _2185_/Q _2220_/Q VGND VGND VPWR VPWR _1259_/B sky130_fd_sc_hd__xor2_1
XFILLER_17_281 VGND VGND VPWR VPWR sky130_fd_sc_hd__decap_4
X_1183_ _2211_/Q _1410_/S VGND VGND VPWR VPWR _1183_/Y sky130_fd_sc_hd__nor2b_1
X_0967_ _2141_/Q _0966_/Y _0963_/Y _1661_/B1 VGND VGND VPWR VPWR _0967_/X sky130_fd_sc_hd__a211o_1
XPHY_EDGE_ROW_12_Right_12 VGND VGND VPWR VPWR sky130_fd_sc_hd__decap_3
X_1519_ _1624_/A _1624_/B _1519_/C VGND VGND VPWR VPWR _1896_/D sky130_fd_sc_hd__nor3_1
XPHY_EDGE_ROW_21_Right_21 VGND VGND VPWR VPWR sky130_fd_sc_hd__decap_3
XFILLER_15_218 VGND VGND VPWR VPWR sky130_fd_sc_hd__fill_1
XTAP_TAPCELL_ROW_25_257 VGND VPWR sky130_fd_sc_hd__tapvpwrvgnd_1
XPHY_EDGE_ROW_30_Right_30 VGND VGND VPWR VPWR sky130_fd_sc_hd__decap_3
XTAP_TAPCELL_ROW_16_213 VGND VPWR sky130_fd_sc_hd__tapvpwrvgnd_1
XFILLER_14_251 VGND VGND VPWR VPWR sky130_fd_sc_hd__fill_1
X_1870_ _2097_/Q hold273/X _1887_/S VGND VGND VPWR VPWR _2097_/D sky130_fd_sc_hd__mux2_1
XFILLER_43_3 VGND VGND VPWR VPWR sky130_fd_sc_hd__fill_1
XTAP_TAPCELL_ROW_39_327 VGND VPWR sky130_fd_sc_hd__tapvpwrvgnd_1
X_1304_ _2178_/Q _1304_/B _1309_/B VGND VGND VPWR VPWR _1304_/X sky130_fd_sc_hd__xor3_1
X_1235_ _1410_/S _2196_/Q _1234_/Y _1661_/B1 VGND VGND VPWR VPWR _1235_/X sky130_fd_sc_hd__a211o_1
X_1166_ _1368_/S _2173_/Q _1285_/B1 VGND VGND VPWR VPWR _1166_/Y sky130_fd_sc_hd__o21ai_0
X_1097_ _1267_/A2 _1096_/Y _1093_/Y VGND VGND VPWR VPWR _2172_/D sky130_fd_sc_hd__o21ai_0
XTAP_TAPCELL_ROW_30_282 VGND VPWR sky130_fd_sc_hd__tapvpwrvgnd_1
X_1999_ _2224_/CLK _1999_/D fanout88/X VGND VGND VPWR VPWR _1999_/Q sky130_fd_sc_hd__dfrtp_1
XFILLER_11_265 VGND VGND VPWR VPWR sky130_fd_sc_hd__fill_2
XFILLER_11_276 VGND VGND VPWR VPWR sky130_fd_sc_hd__decap_4
XFILLER_7_225 VGND VGND VPWR VPWR sky130_fd_sc_hd__fill_1
XTAP_TAPCELL_ROW_53_396 VGND VPWR sky130_fd_sc_hd__tapvpwrvgnd_1
Xwire112 _1350_/Y VGND VGND VPWR VPWR _1352_/B sky130_fd_sc_hd__clkbuf_2
XFILLER_7_258 VGND VGND VPWR VPWR sky130_fd_sc_hd__decap_12
X_1020_ wire46/X _1044_/A _1015_/A _1015_/B VGND VGND VPWR VPWR _1057_/D sky130_fd_sc_hd__o211ai_1
XTAP_TAPCELL_ROW_44_352 VGND VPWR sky130_fd_sc_hd__tapvpwrvgnd_1
X_1922_ clkload8/A _1922_/D VGND VGND VPWR VPWR _1922_/Q sky130_fd_sc_hd__dfxtp_1
Xfanout8 _1640_/X VGND VGND VPWR VPWR fanout8/X sky130_fd_sc_hd__clkdlybuf4s50_1
X_1853_ _0972_/A _2081_/Q _1856_/S VGND VGND VPWR VPWR _2081_/D sky130_fd_sc_hd__mux2_1
X_1784_ _2022_/Q _1812_/A wire35/X VGND VGND VPWR VPWR _2022_/D sky130_fd_sc_hd__mux2_1
X_2198_ _2230_/CLK _2198_/D VGND VGND VPWR VPWR _2198_/Q sky130_fd_sc_hd__dfxtp_1
X_1218_ _2013_/Q _1285_/B1 _1217_/X VGND VGND VPWR VPWR _2206_/D sky130_fd_sc_hd__o21a_1
X_1149_ _2022_/Q _1324_/A2 _1147_/Y _1148_/Y VGND VGND VPWR VPWR _2215_/D sky130_fd_sc_hd__o2bb2ai_1
XFILLER_29_86 VGND VGND VPWR VPWR sky130_fd_sc_hd__fill_2
XTAP_TAPCELL_ROW_58_422 VGND VPWR sky130_fd_sc_hd__tapvpwrvgnd_1
XFILLER_43_165 VGND VGND VPWR VPWR sky130_fd_sc_hd__decap_3
Xdigital_top_225 VGND VGND VPWR VPWR digital_top_225/HI duio_out[3] sky130_fd_sc_hd__conb_1
Xdigital_top_236 VGND VGND VPWR VPWR digital_top_236/HI duo_out[6] sky130_fd_sc_hd__conb_1
X_2146__238 VGND VGND VPWR VPWR _2146_/D _2146__238/LO sky130_fd_sc_hd__conb_1
X_1003_ _1016_/A _1927_/Q _1022_/C _1654_/A _1006_/B VGND VGND VPWR VPWR _1060_/B
+ sky130_fd_sc_hd__o2111ai_1
X_2121_ clkload7/A _2121_/D _2145_/SET_B VGND VGND VPWR VPWR _2121_/Q sky130_fd_sc_hd__dfrtp_1
X_2052_ _2224_/CLK _2052_/D fanout87/X VGND VGND VPWR VPWR _2052_/Q sky130_fd_sc_hd__dfstp_2
X_1905_ clkload0/A _1905_/D VGND VGND VPWR VPWR _1905_/Q sky130_fd_sc_hd__dfxtp_1
XPHY_EDGE_ROW_6_Right_6 VGND VGND VPWR VPWR sky130_fd_sc_hd__decap_3
X_1836_ _0969_/B _2066_/Q wire29/X VGND VGND VPWR VPWR _2066_/D sky130_fd_sc_hd__mux2_1
X_1767_ _1824_/A0 _2008_/Q wire38/A VGND VGND VPWR VPWR _2008_/D sky130_fd_sc_hd__mux2_1
X_1698_ _1984_/Q _1983_/Q _1698_/S VGND VGND VPWR VPWR _1984_/D sky130_fd_sc_hd__mux2_1
XFILLER_25_110 VGND VGND VPWR VPWR sky130_fd_sc_hd__fill_2
XFILLER_0_253 VGND VGND VPWR VPWR sky130_fd_sc_hd__decap_12
XFILLER_48_224 VGND VGND VPWR VPWR sky130_fd_sc_hd__fill_1
XPHY_EDGE_ROW_59_Right_59 VGND VGND VPWR VPWR sky130_fd_sc_hd__decap_3
XTAP_TAPCELL_ROW_61_439 VGND VPWR sky130_fd_sc_hd__tapvpwrvgnd_1
X_1621_ _1941_/Q _1620_/A VGND VGND VPWR VPWR _1622_/A sky130_fd_sc_hd__nor2b_1
X_1552_ _1630_/A _1943_/Q _1552_/B1 VGND VGND VPWR VPWR _1552_/Y sky130_fd_sc_hd__o21ai_0
X_2104_ clkload1/A _2104_/D fanout59/A VGND VGND VPWR VPWR _2104_/Q sky130_fd_sc_hd__dfrtp_1
X_1483_ _1719_/B _2130_/Q _1490_/S VGND VGND VPWR VPWR _2130_/D sky130_fd_sc_hd__mux2_1
XFILLER_22_124 VGND VGND VPWR VPWR sky130_fd_sc_hd__fill_1
X_2035_ clkload4/A _2035_/D wire68/X VGND VGND VPWR VPWR _2035_/Q sky130_fd_sc_hd__dfrtp_1
X_1819_ _1819_/A0 _2052_/Q wire31/X VGND VGND VPWR VPWR _2052_/D sky130_fd_sc_hd__mux2_1
XFILLER_13_113 VGND VGND VPWR VPWR sky130_fd_sc_hd__fill_2
XPHY_EDGE_ROW_37_Left_99 VGND VGND VPWR VPWR sky130_fd_sc_hd__decap_3
XFILLER_21_190 VGND VGND VPWR VPWR sky130_fd_sc_hd__fill_1
XPHY_EDGE_ROW_39_Left_101 VGND VGND VPWR VPWR sky130_fd_sc_hd__decap_3
XTAP_TAPCELL_ROW_8_172 VGND VPWR sky130_fd_sc_hd__tapvpwrvgnd_1
XPHY_EDGE_ROW_48_Left_110 VGND VGND VPWR VPWR sky130_fd_sc_hd__decap_3
X_0983_ _2142_/Q _0983_/B VGND VGND VPWR VPWR _0983_/Y sky130_fd_sc_hd__nand2_1
Xfanout118 _1457_/B2 VGND VGND VPWR VPWR _1448_/A2 sky130_fd_sc_hd__clkdlybuf4s50_1
Xfanout129 _0956_/X VGND VGND VPWR VPWR _1287_/A2 sky130_fd_sc_hd__clkdlybuf4s50_1
X_1604_ _1604_/A _1604_/B _1604_/C VGND VGND VPWR VPWR _1915_/D sky130_fd_sc_hd__nor3_1
X_1535_ _1609_/A _1609_/B _1535_/C VGND VGND VPWR VPWR _1900_/D sky130_fd_sc_hd__nor3_1
X_1466_ _2121_/Q hold288/X _1887_/S VGND VGND VPWR VPWR _2121_/D sky130_fd_sc_hd__mux2_1
X_1397_ _1939_/Q _1932_/Q VGND VGND VPWR VPWR _1400_/A sky130_fd_sc_hd__nand2_1
X_2018_ clkload4/A _2018_/D wire68/X VGND VGND VPWR VPWR _2018_/Q sky130_fd_sc_hd__dfstp_2
XTAP_TAPCELL_ROW_11_188 VGND VPWR sky130_fd_sc_hd__tapvpwrvgnd_1
X_1320_ _2181_/Q _1326_/B VGND VGND VPWR VPWR _1321_/A sky130_fd_sc_hd__xor2_1
X_1251_ _0954_/Y _1317_/C1 _1250_/Y VGND VGND VPWR VPWR _2183_/D sky130_fd_sc_hd__o21ai_0
X_1182_ _2033_/Q _1307_/A2 _1180_/Y _1181_/Y VGND VGND VPWR VPWR _2226_/D sky130_fd_sc_hd__o2bb2ai_1
X_0966_ _1016_/A _1625_/A _0966_/C VGND VGND VPWR VPWR _0966_/Y sky130_fd_sc_hd__nor3_1
X_1518_ _1896_/Q _1627_/B _1517_/Y VGND VGND VPWR VPWR _1519_/C sky130_fd_sc_hd__a21oi_1
X_1449_ _1624_/A _1624_/B _1940_/Q _2073_/Q _1451_/B2 VGND VGND VPWR VPWR _1449_/X
+ sky130_fd_sc_hd__o32a_1
XTAP_TAPCELL_ROW_25_258 VGND VPWR sky130_fd_sc_hd__tapvpwrvgnd_1
XFILLER_3_3 VGND VGND VPWR VPWR sky130_fd_sc_hd__fill_1
XFILLER_0_26 VGND VGND VPWR VPWR sky130_fd_sc_hd__fill_2
XFILLER_48_85 VGND VGND VPWR VPWR sky130_fd_sc_hd__decap_4
XPHY_EDGE_ROW_24_Left_86 VGND VGND VPWR VPWR sky130_fd_sc_hd__decap_3
X_1303_ _2195_/Q _2230_/Q VGND VGND VPWR VPWR _1309_/B sky130_fd_sc_hd__xor2_1
XTAP_TAPCELL_ROW_39_328 VGND VPWR sky130_fd_sc_hd__tapvpwrvgnd_1
X_1234_ _1416_/S _2228_/Q VGND VGND VPWR VPWR _1234_/Y sky130_fd_sc_hd__nor2b_1
X_1165_ _2205_/Q _1368_/S VGND VGND VPWR VPWR _1165_/Y sky130_fd_sc_hd__nor2b_1
X_1096_ _1095_/X _2220_/Q _1356_/S VGND VGND VPWR VPWR _1096_/Y sky130_fd_sc_hd__mux2i_1
XTAP_TAPCELL_ROW_22_239 VGND VPWR sky130_fd_sc_hd__tapvpwrvgnd_1
XTAP_TAPCELL_ROW_30_283 VGND VPWR sky130_fd_sc_hd__tapvpwrvgnd_1
X_0949_ _1652_/B VGND VGND VPWR VPWR _1044_/A sky130_fd_sc_hd__inv_1
X_1998_ _2224_/CLK _1998_/D wire86/X VGND VGND VPWR VPWR _1998_/Q sky130_fd_sc_hd__dfrtp_1
XFILLER_18_33 VGND VGND VPWR VPWR sky130_fd_sc_hd__fill_1
XFILLER_55_185 VGND VGND VPWR VPWR sky130_fd_sc_hd__fill_2
XFILLER_11_222 VGND VGND VPWR VPWR sky130_fd_sc_hd__fill_2
XFILLER_7_215 VGND VGND VPWR VPWR sky130_fd_sc_hd__decap_3
XTAP_TAPCELL_ROW_53_397 VGND VPWR sky130_fd_sc_hd__tapvpwrvgnd_1
Xload_slew107 _1463_/S VGND VGND VPWR VPWR _1882_/S sky130_fd_sc_hd__buf_4
XFILLER_46_152 VGND VGND VPWR VPWR sky130_fd_sc_hd__fill_2
XTAP_TAPCELL_ROW_36_309 VGND VPWR sky130_fd_sc_hd__tapvpwrvgnd_1
Xload_slew65 fanout64/X VGND VGND VPWR VPWR _2058_/SET_B sky130_fd_sc_hd__buf_4
Xload_slew10 _1848_/S VGND VGND VPWR VPWR _1844_/S sky130_fd_sc_hd__clkbuf_2
XTAP_TAPCELL_ROW_44_353 VGND VPWR sky130_fd_sc_hd__tapvpwrvgnd_1
X_1921_ clkload0/A _1921_/D VGND VGND VPWR VPWR _1921_/Q sky130_fd_sc_hd__dfxtp_1
X_1852_ _1721_/A _2080_/Q _1857_/S VGND VGND VPWR VPWR _2080_/D sky130_fd_sc_hd__mux2_1
XFILLER_6_270 VGND VGND VPWR VPWR sky130_fd_sc_hd__decap_12
X_1783_ _2127_/Q _1783_/B _1840_/C _1821_/C VGND VGND VPWR VPWR wire35/A sky130_fd_sc_hd__nor4b_2
X_2197_ clkload3/A _2197_/D VGND VGND VPWR VPWR _2197_/Q sky130_fd_sc_hd__dfxtp_1
X_1217_ _1216_/A _2190_/Q _1216_/Y _1282_/A2 VGND VGND VPWR VPWR _1217_/X sky130_fd_sc_hd__a211o_1
X_1148_ _1331_/S _2167_/Q _1310_/B1 VGND VGND VPWR VPWR _1148_/Y sky130_fd_sc_hd__o21ai_0
X_1079_ _2202_/Q _2173_/Q VGND VGND VPWR VPWR _1085_/B sky130_fd_sc_hd__xor2_1
XFILLER_52_188 VGND VGND VPWR VPWR sky130_fd_sc_hd__fill_2
XFILLER_28_141 VGND VGND VPWR VPWR sky130_fd_sc_hd__fill_1
XFILLER_28_163 VGND VGND VPWR VPWR sky130_fd_sc_hd__decap_3
XTAP_TAPCELL_ROW_58_423 VGND VPWR sky130_fd_sc_hd__tapvpwrvgnd_1
Xclkbuf_1_0__f_dclk clkbuf_0_dclk/X VGND VGND VPWR VPWR clkbuf_leaf_2_dclk/A sky130_fd_sc_hd__clkbuf_16
XTAP_TAPCELL_ROW_41_334 VGND VPWR sky130_fd_sc_hd__tapvpwrvgnd_1
XFILLER_6_58 VGND VGND VPWR VPWR sky130_fd_sc_hd__fill_2
Xdigital_top_226 VGND VGND VPWR VPWR digital_top_226/HI duio_out[4] sky130_fd_sc_hd__conb_1
Xdigital_top_237 VGND VGND VPWR VPWR digital_top_237/HI duo_out[7] sky130_fd_sc_hd__conb_1
XFILLER_3_262 VGND VGND VPWR VPWR sky130_fd_sc_hd__decap_8
X_2120_ clkload1/A _2120_/D load_slew60/X VGND VGND VPWR VPWR _2120_/Q sky130_fd_sc_hd__dfrtp_1
XFILLER_19_163 VGND VGND VPWR VPWR sky130_fd_sc_hd__fill_1
X_1002_ _1656_/B _1925_/Q _1022_/C VGND VGND VPWR VPWR _1021_/C sky130_fd_sc_hd__nor3b_1
X_2051_ _2221_/CLK _2051_/D fanout91/X VGND VGND VPWR VPWR _2051_/Q sky130_fd_sc_hd__dfrtp_1
X_1904_ clkload6/A _1904_/D VGND VGND VPWR VPWR _1904_/Q sky130_fd_sc_hd__dfxtp_1
X_1835_ _0972_/A _2065_/Q wire29/X VGND VGND VPWR VPWR _2065_/D sky130_fd_sc_hd__mux2_1
X_1766_ _1718_/D _2007_/Q wire38/A VGND VGND VPWR VPWR _2007_/D sky130_fd_sc_hd__mux2_1
X_1697_ _1983_/Q _1982_/Q _1698_/S VGND VGND VPWR VPWR _1983_/D sky130_fd_sc_hd__mux2_1
XTAP_TAPCELL_ROW_55_404 VGND VPWR sky130_fd_sc_hd__tapvpwrvgnd_1
XFILLER_15_45 VGND VGND VPWR VPWR sky130_fd_sc_hd__fill_2
XPHY_EDGE_ROW_11_Left_73 VGND VGND VPWR VPWR sky130_fd_sc_hd__decap_3
XFILLER_31_55 VGND VGND VPWR VPWR sky130_fd_sc_hd__fill_1
XFILLER_0_265 VGND VGND VPWR VPWR sky130_fd_sc_hd__decap_12
XFILLER_48_214 VGND VGND VPWR VPWR sky130_fd_sc_hd__decap_3
XFILLER_56_85 VGND VGND VPWR VPWR sky130_fd_sc_hd__fill_2
X_1620_ _1620_/A _1406_/X VGND VGND VPWR VPWR _1622_/C sky130_fd_sc_hd__nor2b_1
X_1551_ _1629_/A _1629_/B _1551_/C VGND VGND VPWR VPWR _1904_/D sky130_fd_sc_hd__nor3_1
X_1482_ _2129_/Q _1479_/Y _1840_/C _1801_/A VGND VGND VPWR VPWR _2129_/D sky130_fd_sc_hd__o2bb2ai_1
X_2103_ clkload8/A _2103_/D fanout69/A VGND VGND VPWR VPWR _2103_/Q sky130_fd_sc_hd__dfrtp_1
X_2034_ clkload4/A _2034_/D wire68/X VGND VGND VPWR VPWR _2034_/Q sky130_fd_sc_hd__dfstp_2
X_1818_ _1818_/A0 _2051_/Q wire31/X VGND VGND VPWR VPWR _2051_/D sky130_fd_sc_hd__mux2_1
Xclkbuf_leaf_4_dclk clkbuf_leaf_9_dclk/A VGND VGND VPWR VPWR clkload9/A sky130_fd_sc_hd__clkbuf_16
X_1749_ _1997_/Q _1749_/B VGND VGND VPWR VPWR _1749_/Y sky130_fd_sc_hd__nor2_1
XTAP_TAPCELL_ROW_8_173 VGND VPWR sky130_fd_sc_hd__tapvpwrvgnd_1
X_0982_ _1658_/A _1654_/A _0980_/Y _1021_/A VGND VGND VPWR VPWR wire52/A sky130_fd_sc_hd__o31ai_1
Xfanout108 _1459_/Y VGND VGND VPWR VPWR _1884_/S sky130_fd_sc_hd__clkdlybuf4s50_1
Xfanout119 _0979_/Y VGND VGND VPWR VPWR _1457_/B2 sky130_fd_sc_hd__clkdlybuf4s50_1
X_1603_ _1915_/Q _1637_/B _1602_/Y VGND VGND VPWR VPWR _1604_/C sky130_fd_sc_hd__a21oi_1
X_1534_ _1900_/Q _1607_/B _1533_/Y VGND VGND VPWR VPWR _1535_/C sky130_fd_sc_hd__a21oi_1
X_1465_ _2120_/Q _1917_/Q _1465_/S VGND VGND VPWR VPWR _2120_/D sky130_fd_sc_hd__mux2_1
X_2017_ clkload5/A _2017_/D _2058_/SET_B VGND VGND VPWR VPWR _2017_/Q sky130_fd_sc_hd__dfstp_2
X_1396_ _1450_/A3 _1394_/X _1395_/Y VGND VGND VPWR VPWR _1939_/D sky130_fd_sc_hd__a21oi_1
XFILLER_10_139 VGND VGND VPWR VPWR sky130_fd_sc_hd__fill_1
XTAP_TAPCELL_ROW_5_154 VGND VPWR sky130_fd_sc_hd__tapvpwrvgnd_1
XFILLER_18_217 VGND VGND VPWR VPWR sky130_fd_sc_hd__fill_1
XFILLER_26_283 VGND VGND VPWR VPWR sky130_fd_sc_hd__fill_2
XFILLER_37_87 VGND VGND VPWR VPWR sky130_fd_sc_hd__fill_1
XFILLER_41_253 VGND VGND VPWR VPWR sky130_fd_sc_hd__fill_1
X_1250_ _1246_/Y _1248_/Y _1249_/Y VGND VGND VPWR VPWR _1250_/Y sky130_fd_sc_hd__o21bai_1
X_1181_ _1392_/S _2178_/Q _1310_/B1 VGND VGND VPWR VPWR _1181_/Y sky130_fd_sc_hd__o21ai_0
X_0965_ _1927_/Q _1656_/B _0965_/C VGND VGND VPWR VPWR _0966_/C sky130_fd_sc_hd__and3_1
X_1517_ _1625_/A _1364_/X _1516_/Y VGND VGND VPWR VPWR _1517_/Y sky130_fd_sc_hd__a21oi_1
X_1448_ _2072_/Q _1448_/A2 _1448_/B1 _2088_/Q _1447_/X VGND VGND VPWR VPWR _1955_/D
+ sky130_fd_sc_hd__o221a_1
X_1379_ _1929_/Q _1936_/Q VGND VGND VPWR VPWR _1382_/A sky130_fd_sc_hd__nand2_1
XFILLER_23_253 VGND VGND VPWR VPWR sky130_fd_sc_hd__decap_4
XFILLER_23_89 VGND VGND VPWR VPWR sky130_fd_sc_hd__fill_2
XFILLER_14_253 VGND VGND VPWR VPWR sky130_fd_sc_hd__decap_12
X_1302_ _2056_/Q _1307_/A2 _1301_/Y VGND VGND VPWR VPWR _2193_/D sky130_fd_sc_hd__a21o_1
X_1233_ _2018_/Q _0983_/B _1232_/X VGND VGND VPWR VPWR _2211_/D sky130_fd_sc_hd__o21a_1
X_1164_ _2027_/Q _1267_/A2 _1162_/Y _1163_/Y VGND VGND VPWR VPWR _2220_/D sky130_fd_sc_hd__o2bb2ai_1
X_1095_ _2188_/Q _1095_/B _1100_/B VGND VGND VPWR VPWR _1095_/X sky130_fd_sc_hd__xnor3_1
X_0948_ _1008_/B VGND VGND VPWR VPWR _1006_/B sky130_fd_sc_hd__inv_1
X_1997_ clkload9/A _1997_/D fanout69/X VGND VGND VPWR VPWR _1997_/Q sky130_fd_sc_hd__dfrtp_1
XFILLER_18_56 VGND VGND VPWR VPWR sky130_fd_sc_hd__fill_2
XTAP_TAPCELL_ROW_53_398 VGND VPWR sky130_fd_sc_hd__tapvpwrvgnd_1
Xload_slew55 fanout54/X VGND VGND VPWR VPWR _2145_/SET_B sky130_fd_sc_hd__buf_4
Xload_slew22 _1958_/DE VGND VGND VPWR VPWR _1950_/DE sky130_fd_sc_hd__buf_2
Xload_slew11 _1842_/S VGND VGND VPWR VPWR _1848_/S sky130_fd_sc_hd__clkbuf_2
XFILLER_61_167 VGND VGND VPWR VPWR sky130_fd_sc_hd__fill_1
X_1920_ clkload4/A _1920_/D VGND VGND VPWR VPWR _1920_/Q sky130_fd_sc_hd__dfxtp_1
X_1851_ _0968_/A _2079_/Q _1857_/S VGND VGND VPWR VPWR _2079_/D sky130_fd_sc_hd__mux2_1
XFILLER_6_282 VGND VGND VPWR VPWR sky130_fd_sc_hd__decap_3
X_1782_ _0969_/C _2021_/Q _1782_/S VGND VGND VPWR VPWR _2021_/D sky130_fd_sc_hd__mux2_1
X_2196_ clkload3/A _2196_/D VGND VGND VPWR VPWR _2196_/Q sky130_fd_sc_hd__dfxtp_1
X_1216_ _1216_/A _2222_/Q VGND VGND VPWR VPWR _1216_/Y sky130_fd_sc_hd__nor2b_1
X_1147_ _2199_/Q _1248_/B VGND VGND VPWR VPWR _1147_/Y sky130_fd_sc_hd__nor2b_1
X_1078_ _1459_/B _1604_/B _2040_/Q VGND VGND VPWR VPWR _1078_/Y sky130_fd_sc_hd__o21ai_0
XTAP_TAPCELL_ROW_50_379 VGND VPWR sky130_fd_sc_hd__tapvpwrvgnd_1
XFILLER_28_197 VGND VGND VPWR VPWR sky130_fd_sc_hd__fill_2
XFILLER_43_178 VGND VGND VPWR VPWR sky130_fd_sc_hd__decap_6
XTAP_TAPCELL_ROW_41_335 VGND VPWR sky130_fd_sc_hd__tapvpwrvgnd_1
Xdigital_top_227 VGND VGND VPWR VPWR digital_top_227/HI duio_out[5] sky130_fd_sc_hd__conb_1
XFILLER_3_252 VGND VGND VPWR VPWR sky130_fd_sc_hd__fill_1
X_2050_ _2221_/CLK _2050_/D _2050_/SET_B VGND VGND VPWR VPWR _2050_/Q sky130_fd_sc_hd__dfstp_2
XFILLER_19_142 VGND VGND VPWR VPWR sky130_fd_sc_hd__fill_1
X_1001_ _1656_/B _1008_/B VGND VGND VPWR VPWR _1022_/B sky130_fd_sc_hd__nor2_1
X_1903_ clkload7/A _1903_/D VGND VGND VPWR VPWR _1903_/Q sky130_fd_sc_hd__dfxtp_1
X_1834_ _1721_/A _2064_/Q wire29/X VGND VGND VPWR VPWR _2064_/D sky130_fd_sc_hd__mux2_1
X_1765_ _1812_/A _2006_/Q wire38/A VGND VGND VPWR VPWR _2006_/D sky130_fd_sc_hd__mux2_1
X_1696_ _1982_/Q _1981_/Q _1698_/S VGND VGND VPWR VPWR _1982_/D sky130_fd_sc_hd__mux2_1
XFILLER_25_101 VGND VGND VPWR VPWR sky130_fd_sc_hd__fill_1
XTAP_TAPCELL_ROW_55_405 VGND VPWR sky130_fd_sc_hd__tapvpwrvgnd_1
X_2179_ clkload4/A _2179_/D VGND VGND VPWR VPWR _2179_/Q sky130_fd_sc_hd__dfxtp_1
XFILLER_0_222 VGND VGND VPWR VPWR sky130_fd_sc_hd__fill_2
XFILLER_0_277 VGND VGND VPWR VPWR sky130_fd_sc_hd__decap_3
X_1550_ _1904_/Q _1627_/B _1549_/Y VGND VGND VPWR VPWR _1551_/C sky130_fd_sc_hd__a21oi_1
X_1481_ _2129_/Q _2128_/Q VGND VGND VPWR VPWR _1840_/C sky130_fd_sc_hd__nand2b_1
XFILLER_11_3 VGND VGND VPWR VPWR sky130_fd_sc_hd__decap_3
X_2102_ _2208_/CLK _2102_/D fanout80/X VGND VGND VPWR VPWR _2102_/Q sky130_fd_sc_hd__dfrtp_1
X_2033_ clkload5/A _2033_/D _2058_/SET_B VGND VGND VPWR VPWR _2033_/Q sky130_fd_sc_hd__dfstp_2
XTAP_TAPCELL_ROW_60_430 VGND VPWR sky130_fd_sc_hd__tapvpwrvgnd_1
XFILLER_30_170 VGND VGND VPWR VPWR sky130_fd_sc_hd__decap_4
X_1817_ _1817_/A0 _2050_/Q wire31/X VGND VGND VPWR VPWR _2050_/D sky130_fd_sc_hd__mux2_1
X_1748_ _1747_/B _1745_/Y _1746_/Y _1747_/Y VGND VGND VPWR VPWR _1996_/D sky130_fd_sc_hd__a31oi_1
X_1679_ _1971_/Q _1673_/X _1687_/B1 _1678_/Y VGND VGND VPWR VPWR _1971_/D sky130_fd_sc_hd__a2bb2oi_1
XFILLER_45_218 VGND VGND VPWR VPWR sky130_fd_sc_hd__fill_2
XFILLER_29_281 VGND VGND VPWR VPWR sky130_fd_sc_hd__decap_4
XFILLER_44_284 VGND VGND VPWR VPWR sky130_fd_sc_hd__fill_1
X_0981_ _1658_/A _1654_/A _0980_/Y _1021_/A VGND VGND VPWR VPWR _0981_/X sky130_fd_sc_hd__o31a_1
XFILLER_59_3 VGND VGND VPWR VPWR sky130_fd_sc_hd__fill_2
X_1602_ _1602_/A _1637_/B _1602_/C VGND VGND VPWR VPWR _1602_/Y sky130_fd_sc_hd__nor3_1
X_1533_ _1605_/A _1388_/X _1532_/Y VGND VGND VPWR VPWR _1533_/Y sky130_fd_sc_hd__a21oi_1
X_1464_ _2119_/Q _1916_/Q _1882_/S VGND VGND VPWR VPWR _2119_/D sky130_fd_sc_hd__mux2_1
X_1395_ _2088_/Q _1448_/A2 _1448_/B1 _2072_/Q VGND VGND VPWR VPWR _1395_/Y sky130_fd_sc_hd__o22ai_1
X_2016_ clkload2/A _2016_/D _2058_/SET_B VGND VGND VPWR VPWR _2016_/Q sky130_fd_sc_hd__dfstp_2
XFILLER_10_118 VGND VGND VPWR VPWR sky130_fd_sc_hd__fill_1
XTAP_TAPCELL_ROW_5_155 VGND VPWR sky130_fd_sc_hd__tapvpwrvgnd_1
XFILLER_5_177 VGND VGND VPWR VPWR sky130_fd_sc_hd__fill_1
XTAP_TAPCELL_ROW_19_224 VGND VPWR sky130_fd_sc_hd__tapvpwrvgnd_1
X_1180_ _2210_/Q _1392_/S VGND VGND VPWR VPWR _1180_/Y sky130_fd_sc_hd__nor2b_1
XFILLER_32_210 VGND VGND VPWR VPWR sky130_fd_sc_hd__decap_4
X_0964_ _1008_/B _1652_/B _1652_/C VGND VGND VPWR VPWR _0965_/C sky130_fd_sc_hd__and3_1
X_1516_ _1620_/A _1934_/Q _1552_/B1 VGND VGND VPWR VPWR _1516_/Y sky130_fd_sc_hd__o21ai_0
X_1447_ _1639_/A _1639_/B _1939_/Q VGND VGND VPWR VPWR _1447_/X sky130_fd_sc_hd__or3_1
X_1378_ _1442_/A3 _1376_/X _1377_/Y VGND VGND VPWR VPWR _1936_/D sky130_fd_sc_hd__a21oi_1
XFILLER_23_57 VGND VGND VPWR VPWR sky130_fd_sc_hd__fill_2
XFILLER_14_243 VGND VGND VPWR VPWR sky130_fd_sc_hd__decap_8
XFILLER_14_265 VGND VGND VPWR VPWR sky130_fd_sc_hd__fill_2
Xfanout80 fanout81/X VGND VGND VPWR VPWR fanout80/X sky130_fd_sc_hd__clkdlybuf4s50_1
Xfanout91 fanout91/A VGND VGND VPWR VPWR fanout91/X sky130_fd_sc_hd__clkdlybuf4s50_1
X_1301_ _1392_/S _1299_/X _1300_/Y VGND VGND VPWR VPWR _1301_/Y sky130_fd_sc_hd__a21oi_1
X_1232_ _1410_/S _2195_/Q _1231_/Y _1661_/B1 VGND VGND VPWR VPWR _1232_/X sky130_fd_sc_hd__a211o_1
X_1163_ _1210_/A _2172_/Q _1270_/B1 VGND VGND VPWR VPWR _1163_/Y sky130_fd_sc_hd__o21ai_0
X_1094_ _2205_/Q _2176_/Q VGND VGND VPWR VPWR _1100_/B sky130_fd_sc_hd__xor2_1
X_0947_ _1656_/B VGND VGND VPWR VPWR _1654_/A sky130_fd_sc_hd__inv_1
X_1996_ clkload0/A _1996_/D load_slew60/X VGND VGND VPWR VPWR _1996_/Q sky130_fd_sc_hd__dfrtp_1
XFILLER_50_44 VGND VGND VPWR VPWR sky130_fd_sc_hd__fill_1
Xclkload0 clkload0/A VGND VGND VPWR VPWR clkload0/X sky130_fd_sc_hd__clkbuf_1
Xload_slew34 _1791_/S VGND VGND VPWR VPWR _1789_/S sky130_fd_sc_hd__clkbuf_2
X_1850_ _1812_/A _2078_/Q _1856_/S VGND VGND VPWR VPWR _2078_/D sky130_fd_sc_hd__mux2_1
X_1781_ _0969_/D _2020_/Q _1781_/S VGND VGND VPWR VPWR _2020_/D sky130_fd_sc_hd__mux2_1
X_2195_ clkload5/A _2195_/D VGND VGND VPWR VPWR _2195_/Q sky130_fd_sc_hd__dfxtp_1
X_1215_ _2012_/Q _1285_/B1 _1214_/X VGND VGND VPWR VPWR _2205_/D sky130_fd_sc_hd__o21a_1
X_1146_ _2005_/Q _1307_/A2 _1144_/Y _1145_/Y VGND VGND VPWR VPWR _2182_/D sky130_fd_sc_hd__o2bb2ai_1
XFILLER_37_187 VGND VGND VPWR VPWR sky130_fd_sc_hd__fill_2
X_1077_ _1297_/A2 _1076_/Y _1073_/Y VGND VGND VPWR VPWR _2168_/D sky130_fd_sc_hd__o21ai_0
XFILLER_20_36 VGND VGND VPWR VPWR sky130_fd_sc_hd__fill_2
X_1979_ _2161_/CLK _1979_/D fanout73/X VGND VGND VPWR VPWR _1979_/Q sky130_fd_sc_hd__dfrtp_1
XFILLER_43_113 VGND VGND VPWR VPWR sky130_fd_sc_hd__fill_2
XTAP_TAPCELL_ROW_41_336 VGND VPWR sky130_fd_sc_hd__tapvpwrvgnd_1
Xdigital_top_217 VGND VGND VPWR VPWR digital_top_217/HI duio_oe[1] sky130_fd_sc_hd__conb_1
Xdigital_top_228 VGND VGND VPWR VPWR digital_top_228/HI duio_out[6] sky130_fd_sc_hd__conb_1
Xdigital_top_239 VGND VGND VPWR VPWR duio_oe[2] digital_top_239/LO sky130_fd_sc_hd__conb_1
XFILLER_10_91 VGND VGND VPWR VPWR sky130_fd_sc_hd__fill_1
XFILLER_3_242 VGND VGND VPWR VPWR sky130_fd_sc_hd__fill_2
XFILLER_6_27 VGND VGND VPWR VPWR sky130_fd_sc_hd__fill_1
X_1000_ _1016_/D _1656_/B VGND VGND VPWR VPWR _1060_/C sky130_fd_sc_hd__nand2_1
X_1902_ clkload7/A _1902_/D VGND VGND VPWR VPWR _1902_/Q sky130_fd_sc_hd__dfxtp_1
X_1833_ _0968_/A _2063_/Q wire29/X VGND VGND VPWR VPWR _2063_/D sky130_fd_sc_hd__mux2_1
X_1764_ _1858_/A wire96/A _1821_/C VGND VGND VPWR VPWR wire38/A sky130_fd_sc_hd__nand3_1
X_1695_ _1981_/Q _1980_/Q _1698_/S VGND VGND VPWR VPWR _1981_/D sky130_fd_sc_hd__mux2_1
XTAP_TAPCELL_ROW_55_406 VGND VPWR sky130_fd_sc_hd__tapvpwrvgnd_1
X_2178_ clkload5/A _2178_/D VGND VGND VPWR VPWR _2178_/Q sky130_fd_sc_hd__dfxtp_1
X_1129_ _2212_/Q _2167_/Q VGND VGND VPWR VPWR _1135_/B sky130_fd_sc_hd__xor2_1
XFILLER_25_179 VGND VGND VPWR VPWR sky130_fd_sc_hd__fill_1
XPHY_EDGE_ROW_19_Right_19 VGND VGND VPWR VPWR sky130_fd_sc_hd__decap_3
XFILLER_39_205 VGND VGND VPWR VPWR sky130_fd_sc_hd__decap_8
XPHY_EDGE_ROW_28_Right_28 VGND VGND VPWR VPWR sky130_fd_sc_hd__decap_3
X_1480_ _1774_/D _1478_/C _1479_/Y VGND VGND VPWR VPWR _2128_/D sky130_fd_sc_hd__o21a_1
XPHY_EDGE_ROW_37_Right_37 VGND VGND VPWR VPWR sky130_fd_sc_hd__decap_3
X_2101_ clkload9/A _2101_/D fanout69/X VGND VGND VPWR VPWR _2101_/Q sky130_fd_sc_hd__dfrtp_1
X_2032_ _2208_/CLK _2032_/D wire86/X VGND VGND VPWR VPWR _2032_/Q sky130_fd_sc_hd__dfstp_2
XFILLER_22_105 VGND VGND VPWR VPWR sky130_fd_sc_hd__fill_1
XTAP_TAPCELL_ROW_60_431 VGND VPWR sky130_fd_sc_hd__tapvpwrvgnd_1
XFILLER_30_193 VGND VGND VPWR VPWR sky130_fd_sc_hd__decap_3
XPHY_EDGE_ROW_46_Right_46 VGND VGND VPWR VPWR sky130_fd_sc_hd__decap_3
X_1816_ _1816_/A0 _2049_/Q wire31/X VGND VGND VPWR VPWR _2049_/D sky130_fd_sc_hd__mux2_1
X_1747_ _1996_/Q _1747_/B VGND VGND VPWR VPWR _1747_/Y sky130_fd_sc_hd__nor2_1
X_1678_ _1970_/Q _1991_/Q _1682_/S VGND VGND VPWR VPWR _1678_/Y sky130_fd_sc_hd__mux2i_1
XPHY_EDGE_ROW_55_Right_55 VGND VGND VPWR VPWR sky130_fd_sc_hd__decap_3
XFILLER_3_17 VGND VGND VPWR VPWR sky130_fd_sc_hd__fill_1
X_0980_ _1652_/B _1652_/C _1008_/B VGND VGND VPWR VPWR _0980_/Y sky130_fd_sc_hd__a21oi_1
XTAP_TAPCELL_ROW_14_199 VGND VPWR sky130_fd_sc_hd__tapvpwrvgnd_1
X_1601_ _1937_/Q _1458_/A1 VGND VGND VPWR VPWR _1602_/A sky130_fd_sc_hd__nor2b_1
X_1532_ _1635_/A _1938_/Q _1556_/B1 VGND VGND VPWR VPWR _1532_/Y sky130_fd_sc_hd__o21ai_0
X_1463_ _2118_/Q hold290/X _1463_/S VGND VGND VPWR VPWR _2118_/D sky130_fd_sc_hd__mux2_1
X_1394_ _1394_/A _1394_/B _1394_/C VGND VGND VPWR VPWR _1394_/X sky130_fd_sc_hd__xnor3_1
X_2015_ _2208_/CLK _2015_/D wire86/X VGND VGND VPWR VPWR _2015_/Q sky130_fd_sc_hd__dfrtp_1
XFILLER_12_37 VGND VGND VPWR VPWR sky130_fd_sc_hd__fill_2
XTAP_TAPCELL_ROW_5_156 VGND VPWR sky130_fd_sc_hd__tapvpwrvgnd_1
XFILLER_41_222 VGND VGND VPWR VPWR sky130_fd_sc_hd__fill_2
XFILLER_53_55 VGND VGND VPWR VPWR sky130_fd_sc_hd__fill_1
XTAP_TAPCELL_ROW_28_269 VGND VPWR sky130_fd_sc_hd__tapvpwrvgnd_1
XFILLER_5_167 VGND VGND VPWR VPWR sky130_fd_sc_hd__fill_1
XTAP_TAPCELL_ROW_19_225 VGND VPWR sky130_fd_sc_hd__tapvpwrvgnd_1
X_0963_ _0958_/Y _1658_/A _1021_/A _1656_/A VGND VGND VPWR VPWR _0963_/Y sky130_fd_sc_hd__a31oi_1
XTAP_TAPCELL_ROW_10_180 VGND VPWR sky130_fd_sc_hd__tapvpwrvgnd_1
X_1515_ _1634_/A _1634_/B _1515_/C VGND VGND VPWR VPWR _1895_/D sky130_fd_sc_hd__nor3_1
X_1446_ _2071_/Q _1457_/B2 _1448_/B1 _2087_/Q _1445_/X VGND VGND VPWR VPWR _1954_/D
+ sky130_fd_sc_hd__o221a_1
X_1377_ _2085_/Q _1457_/B2 _1448_/B1 _2069_/Q VGND VGND VPWR VPWR _1377_/Y sky130_fd_sc_hd__o22ai_1
XTAP_TAPCELL_ROW_33_294 VGND VPWR sky130_fd_sc_hd__tapvpwrvgnd_1
XFILLER_0_29 VGND VGND VPWR VPWR sky130_fd_sc_hd__fill_2
XFILLER_14_277 VGND VGND VPWR VPWR sky130_fd_sc_hd__decap_8
XTAP_TAPCELL_ROW_24_250 VGND VPWR sky130_fd_sc_hd__tapvpwrvgnd_1
Xfanout81 fanout82/X VGND VGND VPWR VPWR fanout81/X sky130_fd_sc_hd__clkdlybuf4s50_1
XFILLER_43_7 VGND VGND VPWR VPWR sky130_fd_sc_hd__fill_2
X_1300_ _1240_/A _2209_/Q _1300_/B1 VGND VGND VPWR VPWR _1300_/Y sky130_fd_sc_hd__o21ai_0
X_1231_ _1410_/S _2227_/Q VGND VGND VPWR VPWR _1231_/Y sky130_fd_sc_hd__nor2b_1
X_1162_ _2204_/Q _1210_/A VGND VGND VPWR VPWR _1162_/Y sky130_fd_sc_hd__nor2b_1
XTAP_TAPCELL_ROW_47_364 VGND VPWR sky130_fd_sc_hd__tapvpwrvgnd_1
X_1093_ _1459_/B _1604_/B hold271/X VGND VGND VPWR VPWR _1093_/Y sky130_fd_sc_hd__o21ai_0
XFILLER_9_281 VGND VGND VPWR VPWR sky130_fd_sc_hd__decap_4
X_0946_ _1927_/Q VGND VGND VPWR VPWR _1658_/A sky130_fd_sc_hd__inv_1
X_1995_ clkload6/A _1995_/D load_slew58/X VGND VGND VPWR VPWR _1995_/Q sky130_fd_sc_hd__dfrtp_1
X_1429_ _1639_/A _1639_/B _1930_/Q _2063_/Q _1448_/A2 VGND VGND VPWR VPWR _1429_/X
+ sky130_fd_sc_hd__o32a_1
XFILLER_55_166 VGND VGND VPWR VPWR sky130_fd_sc_hd__fill_2
XTAP_TAPCELL_ROW_38_320 VGND VPWR sky130_fd_sc_hd__tapvpwrvgnd_1
XFILLER_34_35 VGND VGND VPWR VPWR sky130_fd_sc_hd__decap_4
Xclkload1 clkload1/A VGND VGND VPWR VPWR clkload1/Y sky130_fd_sc_hd__clkinv_2
XFILLER_46_144 VGND VGND VPWR VPWR sky130_fd_sc_hd__fill_1
Xload_slew79 fanout78/X VGND VGND VPWR VPWR load_slew79/X sky130_fd_sc_hd__clkbuf_4
X_1780_ _0969_/A _2019_/Q _1781_/S VGND VGND VPWR VPWR _2019_/D sky130_fd_sc_hd__mux2_1
X_2194_ clkload5/A _2194_/D VGND VGND VPWR VPWR _2194_/Q sky130_fd_sc_hd__dfxtp_1
X_1214_ _1368_/S _2189_/Q _1213_/Y _1282_/A2 VGND VGND VPWR VPWR _1214_/X sky130_fd_sc_hd__a211o_1
X_1145_ _1331_/S _1143_/X _1310_/B1 VGND VGND VPWR VPWR _1145_/Y sky130_fd_sc_hd__o21ai_0
XFILLER_52_147 VGND VGND VPWR VPWR sky130_fd_sc_hd__fill_1
X_1076_ _1075_/X _2216_/Q _1344_/S VGND VGND VPWR VPWR _1076_/Y sky130_fd_sc_hd__mux2i_1
Xclkbuf_leaf_7_dclk clkbuf_leaf_9_dclk/A VGND VGND VPWR VPWR _2208_/CLK sky130_fd_sc_hd__clkbuf_16
X_1978_ _2166_/CLK _1978_/D fanout80/X VGND VGND VPWR VPWR _1978_/Q sky130_fd_sc_hd__dfrtp_1
XFILLER_43_158 VGND VGND VPWR VPWR sky130_fd_sc_hd__fill_1
XFILLER_43_169 VGND VGND VPWR VPWR sky130_fd_sc_hd__fill_1
XTAP_TAPCELL_ROW_41_337 VGND VPWR sky130_fd_sc_hd__tapvpwrvgnd_1
Xdigital_top_218 VGND VGND VPWR VPWR digital_top_218/HI duio_oe[3] sky130_fd_sc_hd__conb_1
Xdigital_top_229 VGND VGND VPWR VPWR digital_top_229/HI duio_out[7] sky130_fd_sc_hd__conb_1
X_1901_ clkload1/A _1901_/D VGND VGND VPWR VPWR _1901_/Q sky130_fd_sc_hd__dfxtp_1
X_1832_ _1812_/A _2062_/Q wire29/X VGND VGND VPWR VPWR _2062_/D sky130_fd_sc_hd__mux2_1
X_1763_ _0969_/C _2005_/Q wire39/X VGND VGND VPWR VPWR _2005_/D sky130_fd_sc_hd__mux2_1
X_1694_ _1980_/Q _1979_/Q _1694_/S VGND VGND VPWR VPWR _1980_/D sky130_fd_sc_hd__mux2_1
XFILLER_25_125 VGND VGND VPWR VPWR sky130_fd_sc_hd__decap_4
XTAP_TAPCELL_ROW_55_407 VGND VPWR sky130_fd_sc_hd__tapvpwrvgnd_1
X_2177_ _2230_/CLK _2177_/D VGND VGND VPWR VPWR _2177_/Q sky130_fd_sc_hd__dfxtp_1
X_1128_ _1629_/A _1629_/B hold287/X VGND VGND VPWR VPWR _1128_/Y sky130_fd_sc_hd__o21ai_0
X_1059_ _1048_/C _1923_/Q _1025_/B VGND VGND VPWR VPWR _1060_/A sky130_fd_sc_hd__o21ai_0
XFILLER_31_47 VGND VGND VPWR VPWR sky130_fd_sc_hd__decap_8
XFILLER_40_139 VGND VGND VPWR VPWR sky130_fd_sc_hd__fill_1
XFILLER_0_235 VGND VGND VPWR VPWR sky130_fd_sc_hd__decap_12
X_2100_ clkload0/A _2100_/D load_slew60/X VGND VGND VPWR VPWR _2100_/Q sky130_fd_sc_hd__dfrtp_1
X_2031_ _2208_/CLK _2031_/D wire86/X VGND VGND VPWR VPWR _2031_/Q sky130_fd_sc_hd__dfstp_2
XTAP_TAPCELL_ROW_60_432 VGND VPWR sky130_fd_sc_hd__tapvpwrvgnd_1
X_1815_ _1824_/A0 _2048_/Q wire31/A VGND VGND VPWR VPWR _2048_/D sky130_fd_sc_hd__mux2_1
XPHY_EDGE_ROW_15_Left_77 VGND VGND VPWR VPWR sky130_fd_sc_hd__decap_3
X_1746_ _2124_/Q _1746_/A2 wire93/X _2116_/Q _2108_/Q wire97/X VGND VGND VPWR VPWR
+ _1746_/Y sky130_fd_sc_hd__a222oi_1
X_1677_ _1970_/Q _1673_/X _1687_/B1 _1676_/Y VGND VGND VPWR VPWR _1970_/D sky130_fd_sc_hd__a2bb2oi_1
X_2229_ _2230_/CLK _2229_/D VGND VGND VPWR VPWR _2229_/Q sky130_fd_sc_hd__dfxtp_1
XFILLER_44_253 VGND VGND VPWR VPWR sky130_fd_sc_hd__decap_3
XFILLER_12_161 VGND VGND VPWR VPWR sky130_fd_sc_hd__decap_3
XFILLER_16_91 VGND VGND VPWR VPWR sky130_fd_sc_hd__fill_1
X_1600_ _1600_/A _1382_/X VGND VGND VPWR VPWR _1602_/C sky130_fd_sc_hd__nor2b_1
X_1531_ _1609_/A _1609_/B _1531_/C VGND VGND VPWR VPWR _1899_/D sky130_fd_sc_hd__nor3_1
X_1462_ _2117_/Q _1914_/Q _1882_/S VGND VGND VPWR VPWR _2117_/D sky130_fd_sc_hd__mux2_1
X_1393_ _1937_/Q _1955_/Q VGND VGND VPWR VPWR _1394_/C sky130_fd_sc_hd__xor2_1
X_2014_ _2223_/CLK _2014_/D wire86/X VGND VGND VPWR VPWR _2014_/Q sky130_fd_sc_hd__dfstp_2
X_1729_ _2120_/Q wire96/X wire94/X _2112_/Q VGND VGND VPWR VPWR _1729_/Y sky130_fd_sc_hd__a22oi_1
XFILLER_26_253 VGND VGND VPWR VPWR sky130_fd_sc_hd__fill_1
XFILLER_37_57 VGND VGND VPWR VPWR sky130_fd_sc_hd__fill_1
XTAP_TAPCELL_ROW_5_157 VGND VPWR sky130_fd_sc_hd__tapvpwrvgnd_1
XFILLER_5_102 VGND VGND VPWR VPWR sky130_fd_sc_hd__fill_2
XFILLER_17_231 VGND VGND VPWR VPWR sky130_fd_sc_hd__fill_1
XTAP_TAPCELL_ROW_19_226 VGND VPWR sky130_fd_sc_hd__tapvpwrvgnd_1
X_0962_ _2141_/Q _1625_/A VGND VGND VPWR VPWR _1656_/A sky130_fd_sc_hd__nand2_1
XTAP_TAPCELL_ROW_10_181 VGND VPWR sky130_fd_sc_hd__tapvpwrvgnd_1
X_1514_ _1895_/Q _1617_/B _1513_/Y VGND VGND VPWR VPWR _1515_/C sky130_fd_sc_hd__a21oi_1
X_1445_ _1609_/A _1609_/B _1938_/Q VGND VGND VPWR VPWR _1445_/X sky130_fd_sc_hd__or3_1
X_1376_ _1376_/A _1376_/B _1376_/C VGND VGND VPWR VPWR _1376_/X sky130_fd_sc_hd__xnor3_1
XFILLER_23_267 VGND VGND VPWR VPWR sky130_fd_sc_hd__fill_1
XTAP_TAPCELL_ROW_33_295 VGND VPWR sky130_fd_sc_hd__tapvpwrvgnd_1
XPHY_EDGE_ROW_18_Left_80 VGND VGND VPWR VPWR sky130_fd_sc_hd__decap_3
XPHY_EDGE_ROW_45_Left_107 VGND VGND VPWR VPWR sky130_fd_sc_hd__decap_3
XFILLER_58_186 VGND VGND VPWR VPWR sky130_fd_sc_hd__fill_1
XFILLER_58_197 VGND VGND VPWR VPWR sky130_fd_sc_hd__fill_1
XFILLER_13_70 VGND VGND VPWR VPWR sky130_fd_sc_hd__fill_2
XFILLER_13_81 VGND VGND VPWR VPWR sky130_fd_sc_hd__fill_2
XPHY_EDGE_ROW_54_Left_116 VGND VGND VPWR VPWR sky130_fd_sc_hd__decap_3
XTAP_TAPCELL_ROW_24_251 VGND VPWR sky130_fd_sc_hd__tapvpwrvgnd_1
Xfanout71 fanout82/X VGND VGND VPWR VPWR fanout71/X sky130_fd_sc_hd__clkdlybuf4s50_1
Xfanout82 _1888_/X VGND VGND VPWR VPWR fanout82/X sky130_fd_sc_hd__clkdlybuf4s50_1
X_1230_ _2017_/Q _1450_/A3 _1229_/X VGND VGND VPWR VPWR _2210_/D sky130_fd_sc_hd__o21a_1
X_1161_ hold259/X _1267_/A2 _1159_/Y _1160_/Y VGND VGND VPWR VPWR _2219_/D sky130_fd_sc_hd__o2bb2ai_1
X_1092_ hold270/X _1267_/A2 _1090_/Y _1091_/Y VGND VGND VPWR VPWR _2171_/D sky130_fd_sc_hd__o2bb2ai_1
XTAP_TAPCELL_ROW_47_365 VGND VPWR sky130_fd_sc_hd__tapvpwrvgnd_1
X_1994_ clkload7/A _1994_/D _2145_/SET_B VGND VGND VPWR VPWR _1994_/Q sky130_fd_sc_hd__dfrtp_1
X_0945_ _1016_/A VGND VGND VPWR VPWR _1021_/A sky130_fd_sc_hd__inv_1
X_1428_ _1458_/A1 _2078_/Q _1450_/A3 _1427_/X VGND VGND VPWR VPWR _1945_/D sky130_fd_sc_hd__o31a_1
XFILLER_18_48 VGND VGND VPWR VPWR sky130_fd_sc_hd__decap_8
XTAP_TAPCELL_ROW_38_321 VGND VPWR sky130_fd_sc_hd__tapvpwrvgnd_1
X_1359_ _2082_/Q _1451_/B2 _1456_/B1 _2066_/Q VGND VGND VPWR VPWR _1359_/Y sky130_fd_sc_hd__o22ai_1
Xclkload2 clkload2/A VGND VGND VPWR VPWR clkload2/X sky130_fd_sc_hd__clkbuf_8
XFILLER_59_55 VGND VGND VPWR VPWR sky130_fd_sc_hd__fill_1
XPHY_EDGE_ROW_3_Left_65 VGND VGND VPWR VPWR sky130_fd_sc_hd__decap_3
Xload_slew36 wire35/A VGND VGND VPWR VPWR _1791_/S sky130_fd_sc_hd__clkbuf_2
Xload_slew25 _1960_/DE VGND VGND VPWR VPWR _1955_/DE sky130_fd_sc_hd__buf_4
XFILLER_46_178 VGND VGND VPWR VPWR sky130_fd_sc_hd__fill_2
Xload_slew58 fanout57/X VGND VGND VPWR VPWR load_slew58/X sky130_fd_sc_hd__buf_4
XTAP_TAPCELL_ROW_52_390 VGND VPWR sky130_fd_sc_hd__tapvpwrvgnd_1
XFILLER_27_3 VGND VGND VPWR VPWR sky130_fd_sc_hd__fill_2
X_1213_ _1368_/S _2221_/Q VGND VGND VPWR VPWR _1213_/Y sky130_fd_sc_hd__nor2b_1
X_2193_ _2230_/CLK _2193_/D VGND VGND VPWR VPWR _2193_/Q sky130_fd_sc_hd__dfxtp_1
X_1144_ _2230_/Q _1248_/B VGND VGND VPWR VPWR _1144_/Y sky130_fd_sc_hd__nor2b_1
X_1075_ _2184_/Q _1075_/B _1080_/B VGND VGND VPWR VPWR _1075_/X sky130_fd_sc_hd__xnor3_1
X_1977_ _2161_/CLK _1977_/D wire75/X VGND VGND VPWR VPWR _2256_/A sky130_fd_sc_hd__dfstp_2
XFILLER_20_27 VGND VGND VPWR VPWR sky130_fd_sc_hd__fill_1
XTAP_TAPCELL_ROW_41_338 VGND VPWR sky130_fd_sc_hd__tapvpwrvgnd_1
Xdigital_top_219 VGND VGND VPWR VPWR digital_top_219/HI duio_oe[4] sky130_fd_sc_hd__conb_1
X_1900_ clkload9/A _1900_/D VGND VGND VPWR VPWR _1900_/Q sky130_fd_sc_hd__dfxtp_1
X_1831_ _1858_/A _1858_/B wire96/A _1858_/D VGND VGND VPWR VPWR wire29/A sky130_fd_sc_hd__nand4_1
X_1762_ _0969_/D _2004_/Q wire39/X VGND VGND VPWR VPWR _2004_/D sky130_fd_sc_hd__mux2_1
X_1693_ _1979_/Q _1978_/Q _1694_/S VGND VGND VPWR VPWR _1979_/D sky130_fd_sc_hd__mux2_1
X_2176_ _2224_/CLK _2176_/D VGND VGND VPWR VPWR _2176_/Q sky130_fd_sc_hd__dfxtp_1
XTAP_TAPCELL_ROW_55_408 VGND VPWR sky130_fd_sc_hd__tapvpwrvgnd_1
X_1127_ _2001_/Q _1307_/A2 _1125_/Y _1126_/Y VGND VGND VPWR VPWR _2178_/D sky130_fd_sc_hd__o2bb2ai_1
X_1058_ _1010_/Y _1018_/Y _1644_/B _1015_/A _1015_/B VGND VGND VPWR VPWR _1058_/Y
+ sky130_fd_sc_hd__o2111ai_1
XFILLER_33_192 VGND VGND VPWR VPWR sky130_fd_sc_hd__decap_4
XFILLER_0_225 VGND VGND VPWR VPWR sky130_fd_sc_hd__decap_4
XFILLER_0_247 VGND VGND VPWR VPWR sky130_fd_sc_hd__decap_4
XPHY_EDGE_ROW_1_Right_1 VGND VGND VPWR VPWR sky130_fd_sc_hd__decap_3
XFILLER_56_251 VGND VGND VPWR VPWR sky130_fd_sc_hd__fill_1
XFILLER_56_284 VGND VGND VPWR VPWR sky130_fd_sc_hd__fill_1
XFILLER_16_159 VGND VGND VPWR VPWR sky130_fd_sc_hd__fill_2
XFILLER_39_218 VGND VGND VPWR VPWR sky130_fd_sc_hd__decap_6
X_2030_ _2224_/CLK _2030_/D fanout83/X VGND VGND VPWR VPWR _2030_/Q sky130_fd_sc_hd__dfstp_2
XTAP_TAPCELL_ROW_60_433 VGND VPWR sky130_fd_sc_hd__tapvpwrvgnd_1
X_1814_ _1718_/D _2047_/Q wire31/A VGND VGND VPWR VPWR _2047_/D sky130_fd_sc_hd__mux2_1
X_1745_ _2100_/Q _1745_/B VGND VGND VPWR VPWR _1745_/Y sky130_fd_sc_hd__nand2_1
X_1676_ _1985_/Q _1986_/Q _1987_/Q _1990_/Q VGND VGND VPWR VPWR _1676_/Y sky130_fd_sc_hd__nor4_1
XFILLER_26_26 VGND VGND VPWR VPWR sky130_fd_sc_hd__fill_2
X_2228_ clkload5/A _2228_/D VGND VGND VPWR VPWR _2228_/Q sky130_fd_sc_hd__dfxtp_1
X_2159_ _2161_/CLK input2/X wire75/X VGND VGND VPWR VPWR _2159_/Q sky130_fd_sc_hd__dfstp_2
XFILLER_13_129 VGND VGND VPWR VPWR sky130_fd_sc_hd__fill_1
XFILLER_42_14 VGND VGND VPWR VPWR sky130_fd_sc_hd__fill_1
XPHY_EDGE_ROW_32_Left_94 VGND VGND VPWR VPWR sky130_fd_sc_hd__decap_3
X_1530_ _1899_/Q _1607_/B _1529_/Y VGND VGND VPWR VPWR _1531_/C sky130_fd_sc_hd__a21oi_1
X_1461_ _2116_/Q hold289/X _1887_/S VGND VGND VPWR VPWR _2116_/D sky130_fd_sc_hd__mux2_1
X_1392_ _2193_/Q _2177_/Q _1392_/S VGND VGND VPWR VPWR _1394_/B sky130_fd_sc_hd__mux2i_1
X_2013_ _2224_/CLK _2013_/D fanout87/X VGND VGND VPWR VPWR _2013_/Q sky130_fd_sc_hd__dfrtp_1
X_1728_ _1749_/B _1725_/Y _1726_/Y _1727_/Y VGND VGND VPWR VPWR _1991_/D sky130_fd_sc_hd__a31oi_1
XTAP_TAPCELL_ROW_5_158 VGND VPWR sky130_fd_sc_hd__tapvpwrvgnd_1
X_1659_ _1927_/Q fanout8/X _1658_/X _1641_/Y _1659_/C1 VGND VGND VPWR VPWR _1927_/D
+ sky130_fd_sc_hd__o221a_1
XFILLER_26_243 VGND VGND VPWR VPWR sky130_fd_sc_hd__fill_1
XTAP_TAPCELL_ROW_19_227 VGND VPWR sky130_fd_sc_hd__tapvpwrvgnd_1
X_0961_ _1021_/A _1658_/A VGND VGND VPWR VPWR _0961_/Y sky130_fd_sc_hd__nand2_1
XFILLER_57_3 VGND VGND VPWR VPWR sky130_fd_sc_hd__fill_2
XTAP_TAPCELL_ROW_10_182 VGND VPWR sky130_fd_sc_hd__tapvpwrvgnd_1
X_1513_ _1615_/A _1358_/X _1512_/Y VGND VGND VPWR VPWR _1513_/Y sky130_fd_sc_hd__a21oi_1
X_1444_ _1600_/A _2086_/Q _1444_/A3 _1443_/X VGND VGND VPWR VPWR _1953_/D sky130_fd_sc_hd__o31a_1
X_1375_ _1934_/Q _1952_/Q VGND VGND VPWR VPWR _1376_/C sky130_fd_sc_hd__xor2_1
XTAP_TAPCELL_ROW_2_139 VGND VPWR sky130_fd_sc_hd__tapvpwrvgnd_1
XFILLER_23_257 VGND VGND VPWR VPWR sky130_fd_sc_hd__fill_1
XFILLER_23_279 VGND VGND VPWR VPWR sky130_fd_sc_hd__fill_1
XTAP_TAPCELL_ROW_33_296 VGND VPWR sky130_fd_sc_hd__tapvpwrvgnd_1
XTAP_TAPCELL_ROW_24_252 VGND VPWR sky130_fd_sc_hd__tapvpwrvgnd_1
Xfanout61 fanout63/X VGND VGND VPWR VPWR fanout61/X sky130_fd_sc_hd__clkdlybuf4s50_1
Xfanout83 wire86/A VGND VGND VPWR VPWR fanout83/X sky130_fd_sc_hd__clkdlybuf4s50_1
XTAP_TAPCELL_ROW_47_366 VGND VPWR sky130_fd_sc_hd__tapvpwrvgnd_1
X_1160_ _1356_/S _2171_/Q _1270_/B1 VGND VGND VPWR VPWR _1160_/Y sky130_fd_sc_hd__o21ai_0
X_1091_ _1356_/S _1089_/X _1270_/B1 VGND VGND VPWR VPWR _1091_/Y sky130_fd_sc_hd__o21ai_0
XFILLER_20_216 VGND VGND VPWR VPWR sky130_fd_sc_hd__decap_3
XFILLER_20_227 VGND VGND VPWR VPWR sky130_fd_sc_hd__decap_4
X_1993_ clkload0/A _1993_/D _2145_/SET_B VGND VGND VPWR VPWR _1993_/Q sky130_fd_sc_hd__dfrtp_1
XFILLER_9_272 VGND VGND VPWR VPWR sky130_fd_sc_hd__decap_8
X_1427_ _1639_/A _1639_/B _1929_/Q _2062_/Q _1448_/A2 VGND VGND VPWR VPWR _1427_/X
+ sky130_fd_sc_hd__o32a_1
X_1358_ _1358_/A _1358_/B _1358_/C VGND VGND VPWR VPWR _1358_/X sky130_fd_sc_hd__xnor3_1
XFILLER_34_59 VGND VGND VPWR VPWR sky130_fd_sc_hd__fill_1
XTAP_TAPCELL_ROW_38_322 VGND VPWR sky130_fd_sc_hd__tapvpwrvgnd_1
X_1289_ _2175_/Q _1289_/B _1294_/B VGND VGND VPWR VPWR _1289_/X sky130_fd_sc_hd__xor3_1
Xclkload3 clkload3/A VGND VGND VPWR VPWR clkload3/Y sky130_fd_sc_hd__inv_6
Xload_slew48 _1669_/S VGND VGND VPWR VPWR _2163_/D sky130_fd_sc_hd__clkbuf_2
XFILLER_24_70 VGND VGND VPWR VPWR sky130_fd_sc_hd__decap_4
XTAP_TAPCELL_ROW_52_391 VGND VPWR sky130_fd_sc_hd__tapvpwrvgnd_1
XFILLER_10_260 VGND VGND VPWR VPWR sky130_fd_sc_hd__decap_8
XFILLER_6_220 VGND VGND VPWR VPWR sky130_fd_sc_hd__fill_1
X_2192_ _2208_/CLK _2192_/D VGND VGND VPWR VPWR _2192_/Q sky130_fd_sc_hd__dfxtp_1
X_1212_ _2011_/Q _1270_/B1 _1211_/X VGND VGND VPWR VPWR _2204_/D sky130_fd_sc_hd__o21a_1
X_1143_ _2198_/Q _1143_/B _1143_/C VGND VGND VPWR VPWR _1143_/X sky130_fd_sc_hd__xnor3_1
X_1074_ _2201_/Q _2172_/Q VGND VGND VPWR VPWR _1080_/B sky130_fd_sc_hd__xnor2_1
X_1976_ _2161_/CLK _1976_/D wire75/X VGND VGND VPWR VPWR _1976_/Q sky130_fd_sc_hd__dfstp_2
XFILLER_61_57 VGND VGND VPWR VPWR sky130_fd_sc_hd__fill_2
XFILLER_3_234 VGND VGND VPWR VPWR sky130_fd_sc_hd__fill_1
XFILLER_3_278 VGND VGND VPWR VPWR sky130_fd_sc_hd__fill_2
X_1830_ _2163_/Q _1858_/B _1858_/D VGND VGND VPWR VPWR _1840_/D sky130_fd_sc_hd__nand3_1
X_1761_ _0969_/A _2003_/Q wire39/X VGND VGND VPWR VPWR _2003_/D sky130_fd_sc_hd__mux2_1
X_1692_ _1978_/Q _1989_/Q _1694_/S VGND VGND VPWR VPWR _1978_/D sky130_fd_sc_hd__mux2_1
X_2175_ _2224_/CLK _2175_/D VGND VGND VPWR VPWR _2175_/Q sky130_fd_sc_hd__dfxtp_1
X_1126_ _1392_/S _1124_/X _1310_/B1 VGND VGND VPWR VPWR _1126_/Y sky130_fd_sc_hd__o21ai_0
X_1057_ _1057_/A _1057_/B _1057_/C _1057_/D VGND VGND VPWR VPWR _1062_/A sky130_fd_sc_hd__nand4_1
X_1959_ clkload6/A _1959_/D _1959_/DE VGND VGND VPWR VPWR _1959_/Q sky130_fd_sc_hd__edfxtp_1
Xclkbuf_leaf_12_dclk clkbuf_leaf_2_dclk/A VGND VGND VPWR VPWR _2230_/CLK sky130_fd_sc_hd__clkbuf_16
XFILLER_30_130 VGND VGND VPWR VPWR sky130_fd_sc_hd__fill_2
XFILLER_30_174 VGND VGND VPWR VPWR sky130_fd_sc_hd__fill_1
X_1813_ _0954_/Y wire31/A _1812_/Y VGND VGND VPWR VPWR _2046_/D sky130_fd_sc_hd__a21oi_1
X_1744_ _1747_/B _1742_/Y _1743_/Y _1741_/Y VGND VGND VPWR VPWR _1995_/D sky130_fd_sc_hd__a31oi_1
XPHY_EDGE_ROW_15_Right_15 VGND VGND VPWR VPWR sky130_fd_sc_hd__decap_3
X_1675_ _1985_/Q _1986_/Q _1987_/Q VGND VGND VPWR VPWR _1686_/S sky130_fd_sc_hd__nor3_2
XFILLER_38_263 VGND VGND VPWR VPWR sky130_fd_sc_hd__decap_4
XPHY_EDGE_ROW_24_Right_24 VGND VGND VPWR VPWR sky130_fd_sc_hd__decap_3
X_2227_ clkload4/A _2227_/D VGND VGND VPWR VPWR _2227_/Q sky130_fd_sc_hd__dfxtp_1
X_2158_ _2161_/CLK _2158_/D wire75/X VGND VGND VPWR VPWR _2158_/Q sky130_fd_sc_hd__dfstp_2
X_2089_ clkload0/A _2089_/D load_slew60/X VGND VGND VPWR VPWR _2089_/Q sky130_fd_sc_hd__dfrtp_1
X_1109_ _2191_/Q _1109_/B _1115_/B VGND VGND VPWR VPWR _1109_/X sky130_fd_sc_hd__xnor3_1
XFILLER_53_277 VGND VGND VPWR VPWR sky130_fd_sc_hd__decap_3
XPHY_EDGE_ROW_33_Right_33 VGND VGND VPWR VPWR sky130_fd_sc_hd__decap_3
XPHY_EDGE_ROW_42_Right_42 VGND VGND VPWR VPWR sky130_fd_sc_hd__decap_3
XFILLER_12_141 VGND VGND VPWR VPWR sky130_fd_sc_hd__fill_2
XFILLER_8_167 VGND VGND VPWR VPWR sky130_fd_sc_hd__fill_1
XPHY_EDGE_ROW_51_Right_51 VGND VGND VPWR VPWR sky130_fd_sc_hd__decap_3
X_1460_ _2115_/Q hold286/X _1885_/S VGND VGND VPWR VPWR _2115_/D sky130_fd_sc_hd__mux2_1
X_1391_ _1938_/Q _1931_/Q VGND VGND VPWR VPWR _1394_/A sky130_fd_sc_hd__nand2_1
XPHY_EDGE_ROW_60_Right_60 VGND VGND VPWR VPWR sky130_fd_sc_hd__decap_3
X_2012_ _2224_/CLK _2012_/D fanout87/X VGND VGND VPWR VPWR _2012_/Q sky130_fd_sc_hd__dfrtp_1
XFILLER_12_18 VGND VGND VPWR VPWR sky130_fd_sc_hd__fill_1
X_1727_ _1991_/Q _1749_/B VGND VGND VPWR VPWR _1727_/Y sky130_fd_sc_hd__nor2_1
X_1658_ _1658_/A _1658_/B VGND VGND VPWR VPWR _1658_/X sky130_fd_sc_hd__xor2_1
X_1589_ _1624_/A _1624_/B _1589_/C VGND VGND VPWR VPWR _1912_/D sky130_fd_sc_hd__nor3_1
XFILLER_41_214 VGND VGND VPWR VPWR sky130_fd_sc_hd__decap_4
XFILLER_53_36 VGND VGND VPWR VPWR sky130_fd_sc_hd__fill_2
XTAP_TAPCELL_ROW_19_228 VGND VPWR sky130_fd_sc_hd__tapvpwrvgnd_1
X_0960_ _1016_/A _1927_/Q VGND VGND VPWR VPWR _1017_/B sky130_fd_sc_hd__nor2_1
XTAP_TAPCELL_ROW_10_183 VGND VPWR sky130_fd_sc_hd__tapvpwrvgnd_1
X_1512_ _1615_/A _1933_/Q _1552_/B1 VGND VGND VPWR VPWR _1512_/Y sky130_fd_sc_hd__o21ai_0
XFILLER_4_170 VGND VGND VPWR VPWR sky130_fd_sc_hd__fill_1
X_1443_ _1604_/A _1604_/B _1937_/Q _2070_/Q _1457_/B2 VGND VGND VPWR VPWR _1443_/X
+ sky130_fd_sc_hd__o32a_1
X_1374_ _2190_/Q _2174_/Q _1374_/S VGND VGND VPWR VPWR _1376_/B sky130_fd_sc_hd__mux2i_1
XFILLER_23_203 VGND VGND VPWR VPWR sky130_fd_sc_hd__fill_1
XFILLER_23_225 VGND VGND VPWR VPWR sky130_fd_sc_hd__decap_3
XTAP_TAPCELL_ROW_33_297 VGND VPWR sky130_fd_sc_hd__tapvpwrvgnd_1
XFILLER_2_118 VGND VGND VPWR VPWR sky130_fd_sc_hd__fill_1
XTAP_TAPCELL_ROW_16_209 VGND VPWR sky130_fd_sc_hd__tapvpwrvgnd_1
XTAP_TAPCELL_ROW_24_253 VGND VPWR sky130_fd_sc_hd__tapvpwrvgnd_1
Xfanout73 fanout77/X VGND VGND VPWR VPWR fanout73/X sky130_fd_sc_hd__clkdlybuf4s50_1
XFILLER_13_61 VGND VGND VPWR VPWR sky130_fd_sc_hd__fill_1
XTAP_TAPCELL_ROW_47_367 VGND VPWR sky130_fd_sc_hd__tapvpwrvgnd_1
X_1090_ _2219_/Q _1356_/S VGND VGND VPWR VPWR _1090_/Y sky130_fd_sc_hd__nor2b_1
Xclkload10 _2161_/CLK VGND VGND VPWR VPWR clkload10/Y sky130_fd_sc_hd__clkinv_2
X_1992_ clkload1/A _1992_/D load_slew60/X VGND VGND VPWR VPWR _1992_/Q sky130_fd_sc_hd__dfrtp_1
XTAP_TAPCELL_ROW_38_323 VGND VPWR sky130_fd_sc_hd__tapvpwrvgnd_1
X_1426_ _1442_/A3 _1424_/X _1425_/Y VGND VGND VPWR VPWR _1944_/D sky130_fd_sc_hd__a21oi_1
X_1357_ _1931_/Q _1949_/Q VGND VGND VPWR VPWR _1358_/C sky130_fd_sc_hd__xor2_1
X_1288_ _2192_/Q _2227_/Q VGND VGND VPWR VPWR _1294_/B sky130_fd_sc_hd__xor2_1
XTAP_TAPCELL_ROW_21_234 VGND VPWR sky130_fd_sc_hd__tapvpwrvgnd_1
Xclkload4 clkload4/A VGND VGND VPWR VPWR clkload4/X sky130_fd_sc_hd__clkbuf_8
Xload_slew49 _1668_/S VGND VGND VPWR VPWR _1669_/S sky130_fd_sc_hd__clkbuf_2
XTAP_TAPCELL_ROW_52_392 VGND VPWR sky130_fd_sc_hd__tapvpwrvgnd_1
X_2191_ _2223_/CLK _2191_/D VGND VGND VPWR VPWR _2191_/Q sky130_fd_sc_hd__dfxtp_1
X_1211_ _1210_/A _2188_/Q _1210_/Y _1267_/A2 VGND VGND VPWR VPWR _1211_/X sky130_fd_sc_hd__a211o_1
X_1142_ _1307_/A2 _1141_/Y _1138_/Y VGND VGND VPWR VPWR _2181_/D sky130_fd_sc_hd__o21ai_0
XFILLER_37_169 VGND VGND VPWR VPWR sky130_fd_sc_hd__fill_2
XTAP_TAPCELL_ROW_35_304 VGND VPWR sky130_fd_sc_hd__tapvpwrvgnd_1
X_1073_ _1459_/B _1604_/B _2039_/Q VGND VGND VPWR VPWR _1073_/Y sky130_fd_sc_hd__o21ai_0
X_1975_ clkload9/A _1975_/D fanout73/X VGND VGND VPWR VPWR _1975_/Q sky130_fd_sc_hd__dfstp_2
X_1409_ _1941_/Q _1934_/Q VGND VGND VPWR VPWR _1412_/A sky130_fd_sc_hd__nand2_1
X_1760_ _0969_/B _2002_/Q wire39/X VGND VGND VPWR VPWR _2002_/D sky130_fd_sc_hd__mux2_1
X_1691_ _2256_/A _1673_/X _1674_/Y _1690_/Y VGND VGND VPWR VPWR _1977_/D sky130_fd_sc_hd__a2bb2oi_1
X_2174_ _2224_/CLK _2174_/D VGND VGND VPWR VPWR _2174_/Q sky130_fd_sc_hd__dfxtp_1
X_1125_ _2226_/Q _1392_/S VGND VGND VPWR VPWR _1125_/Y sky130_fd_sc_hd__nor2b_1
X_1056_ _1035_/D _1035_/A _1035_/B _1032_/Y VGND VGND VPWR VPWR _1057_/B sky130_fd_sc_hd__a31oi_1
X_1958_ clkload6/A _1958_/D _1958_/DE VGND VGND VPWR VPWR _1958_/Q sky130_fd_sc_hd__edfxtp_1
X_1889_ _2139_/Q VGND VGND VPWR VPWR _1889_/X sky130_fd_sc_hd__buf_1
XFILLER_56_253 VGND VGND VPWR VPWR sky130_fd_sc_hd__fill_1
XFILLER_47_253 VGND VGND VPWR VPWR sky130_fd_sc_hd__decap_3
Xmax_cap92 _1888_/X VGND VGND VPWR VPWR fanout91/A sky130_fd_sc_hd__clkbuf_2
X_1812_ _1812_/A wire31/A VGND VGND VPWR VPWR _1812_/Y sky130_fd_sc_hd__nor2_1
X_1743_ _2115_/Q wire93/X _1745_/B _2099_/Q VGND VGND VPWR VPWR _1743_/Y sky130_fd_sc_hd__a22oi_1
X_1674_ _2139_/Q _1988_/Q _2154_/Q VGND VGND VPWR VPWR _1674_/Y sky130_fd_sc_hd__nor3b_2
X_2226_ _2230_/CLK _2226_/D VGND VGND VPWR VPWR _2226_/Q sky130_fd_sc_hd__dfxtp_1
XFILLER_38_253 VGND VGND VPWR VPWR sky130_fd_sc_hd__decap_4
X_2157_ _2161_/CLK _2157_/D wire75/X VGND VGND VPWR VPWR _2157_/Q sky130_fd_sc_hd__dfstp_2
X_2088_ clkload1/A _2088_/D fanout59/A VGND VGND VPWR VPWR _2088_/Q sky130_fd_sc_hd__dfrtp_1
X_1108_ _2208_/Q _2179_/Q VGND VGND VPWR VPWR _1115_/B sky130_fd_sc_hd__xor2_1
X_1039_ _1033_/Y _1035_/Y _1038_/Y _1054_/A VGND VGND VPWR VPWR _1040_/B sky130_fd_sc_hd__a22oi_1
XFILLER_12_175 VGND VGND VPWR VPWR sky130_fd_sc_hd__fill_2
XFILLER_12_186 VGND VGND VPWR VPWR sky130_fd_sc_hd__fill_2
XFILLER_32_82 VGND VGND VPWR VPWR sky130_fd_sc_hd__fill_2
X_1390_ _1444_/A3 _1388_/X _1389_/Y VGND VGND VPWR VPWR _1938_/D sky130_fd_sc_hd__a21oi_1
X_2011_ _2221_/CLK _2011_/D fanout89/X VGND VGND VPWR VPWR _2011_/Q sky130_fd_sc_hd__dfrtp_1
X_1726_ _2103_/Q wire98/X wire42/X _2095_/Q VGND VGND VPWR VPWR _1726_/Y sky130_fd_sc_hd__a22oi_1
X_1657_ _1656_/B _1656_/A _0965_/C _1656_/Y VGND VGND VPWR VPWR _1658_/B sky130_fd_sc_hd__a31oi_1
X_1588_ _1912_/Q _1627_/B _1587_/Y VGND VGND VPWR VPWR _1589_/C sky130_fd_sc_hd__a21oi_1
X_2209_ _2230_/CLK _2209_/D VGND VGND VPWR VPWR _2209_/Q sky130_fd_sc_hd__dfxtp_1
X_1511_ _1634_/A _1634_/B _1511_/C VGND VGND VPWR VPWR _1894_/D sky130_fd_sc_hd__nor3_1
X_1442_ _1458_/A1 _2085_/Q _1442_/A3 _1441_/X VGND VGND VPWR VPWR _1952_/D sky130_fd_sc_hd__o31a_1
X_1373_ _1944_/Q _1935_/Q VGND VGND VPWR VPWR _1376_/A sky130_fd_sc_hd__nand2_1
XTAP_TAPCELL_ROW_33_298 VGND VPWR sky130_fd_sc_hd__tapvpwrvgnd_1
X_1709_ _2164_/Q _2165_/Q _2166_/Q _1708_/X VGND VGND VPWR VPWR _1989_/D sky130_fd_sc_hd__o31a_1
Xfanout63 fanout91/A VGND VGND VPWR VPWR fanout63/X sky130_fd_sc_hd__clkdlybuf4s50_1
Xfanout74 fanout77/X VGND VGND VPWR VPWR wire75/A sky130_fd_sc_hd__clkdlybuf4s50_1
Xfanout85 fanout91/X VGND VGND VPWR VPWR wire86/A sky130_fd_sc_hd__clkdlybuf4s50_1
XFILLER_1_185 VGND VGND VPWR VPWR sky130_fd_sc_hd__fill_1
XTAP_TAPCELL_ROW_47_368 VGND VPWR sky130_fd_sc_hd__tapvpwrvgnd_1
XFILLER_13_281 VGND VGND VPWR VPWR sky130_fd_sc_hd__decap_4
XPHY_EDGE_ROW_41_Left_103 VGND VGND VPWR VPWR sky130_fd_sc_hd__decap_3
XTAP_TAPCELL_ROW_30_279 VGND VPWR sky130_fd_sc_hd__tapvpwrvgnd_1
Xclkload11 _2166_/CLK VGND VGND VPWR VPWR clkload11/X sky130_fd_sc_hd__clkbuf_1
X_1991_ clkload9/A _1991_/D fanout69/X VGND VGND VPWR VPWR _1991_/Q sky130_fd_sc_hd__dfrtp_1
X_1425_ _2093_/Q _1457_/B2 _1448_/B1 _2077_/Q VGND VGND VPWR VPWR _1425_/Y sky130_fd_sc_hd__o22ai_1
XPHY_EDGE_ROW_50_Left_112 VGND VGND VPWR VPWR sky130_fd_sc_hd__decap_3
X_1356_ _2187_/Q _2171_/Q _1356_/S VGND VGND VPWR VPWR _1356_/Y sky130_fd_sc_hd__mux2i_1
X_1287_ hold260/X _1287_/A2 _1286_/Y VGND VGND VPWR VPWR _2190_/D sky130_fd_sc_hd__a21o_1
XFILLER_11_229 VGND VGND VPWR VPWR sky130_fd_sc_hd__decap_12
XTAP_TAPCELL_ROW_21_235 VGND VPWR sky130_fd_sc_hd__tapvpwrvgnd_1
Xclkload5 clkload5/A VGND VGND VPWR VPWR clkload5/Y sky130_fd_sc_hd__clkinv_2
XTAP_TAPCELL_ROW_44_349 VGND VPWR sky130_fd_sc_hd__tapvpwrvgnd_1
Xload_slew28 _1857_/S VGND VGND VPWR VPWR _1856_/S sky130_fd_sc_hd__buf_2
XFILLER_6_244 VGND VGND VPWR VPWR sky130_fd_sc_hd__decap_8
XTAP_TAPCELL_ROW_52_393 VGND VPWR sky130_fd_sc_hd__tapvpwrvgnd_1
X_2190_ _2224_/CLK _2190_/D VGND VGND VPWR VPWR _2190_/Q sky130_fd_sc_hd__dfxtp_1
X_1210_ _1210_/A _2220_/Q VGND VGND VPWR VPWR _1210_/Y sky130_fd_sc_hd__nor2b_1
X_1141_ _1140_/X _2229_/Q _1248_/B VGND VGND VPWR VPWR _1141_/Y sky130_fd_sc_hd__mux2i_1
X_1072_ _1069_/Y _1071_/Y _0952_/Y _1310_/B1 VGND VGND VPWR VPWR _2167_/D sky130_fd_sc_hd__o2bb2ai_1
XTAP_TAPCELL_ROW_35_305 VGND VPWR sky130_fd_sc_hd__tapvpwrvgnd_1
X_1974_ clkload9/A _1974_/D fanout73/X VGND VGND VPWR VPWR _1974_/Q sky130_fd_sc_hd__dfstp_2
XFILLER_29_39 VGND VGND VPWR VPWR sky130_fd_sc_hd__fill_2
XTAP_TAPCELL_ROW_58_419 VGND VPWR sky130_fd_sc_hd__tapvpwrvgnd_1
X_1408_ _0983_/B _1406_/X _1407_/Y VGND VGND VPWR VPWR _1941_/D sky130_fd_sc_hd__a21oi_1
X_1339_ _1944_/Q _1946_/Q VGND VGND VPWR VPWR _1340_/C sky130_fd_sc_hd__xor2_1
XPHY_EDGE_ROW_7_Left_69 VGND VGND VPWR VPWR sky130_fd_sc_hd__decap_3
XFILLER_10_85 VGND VGND VPWR VPWR sky130_fd_sc_hd__decap_6
XFILLER_19_137 VGND VGND VPWR VPWR sky130_fd_sc_hd__fill_2
XFILLER_35_93 VGND VGND VPWR VPWR sky130_fd_sc_hd__decap_8
XTAP_TAPCELL_ROW_40_330 VGND VPWR sky130_fd_sc_hd__tapvpwrvgnd_1
X_1690_ _1976_/Q _1997_/Q _1690_/S VGND VGND VPWR VPWR _1690_/Y sky130_fd_sc_hd__mux2i_1
XFILLER_15_19 VGND VGND VPWR VPWR sky130_fd_sc_hd__fill_2
XFILLER_25_129 VGND VGND VPWR VPWR sky130_fd_sc_hd__fill_1
X_2173_ _2221_/CLK _2173_/D VGND VGND VPWR VPWR _2173_/Q sky130_fd_sc_hd__dfxtp_1
X_1124_ _2194_/Q _1124_/B _1130_/B VGND VGND VPWR VPWR _1124_/X sky130_fd_sc_hd__xnor3_1
X_1055_ _1055_/A _1923_/Q _1055_/C VGND VGND VPWR VPWR _1057_/C sky130_fd_sc_hd__nand3_1
XFILLER_33_184 VGND VGND VPWR VPWR sky130_fd_sc_hd__fill_1
X_1957_ clkload7/A _1957_/D _1959_/DE VGND VGND VPWR VPWR _1957_/Q sky130_fd_sc_hd__edfxtp_1
X_1888_ input1/X _2153_/Q VGND VGND VPWR VPWR _1888_/X sky130_fd_sc_hd__and2_0
XTAP_TAPCELL_ROW_54_400 VGND VPWR sky130_fd_sc_hd__tapvpwrvgnd_1
X_1811_ _1858_/A wire98/A _1821_/C VGND VGND VPWR VPWR wire31/A sky130_fd_sc_hd__nand3_1
X_1742_ _2107_/Q wire97/X _1746_/A2 _2123_/Q VGND VGND VPWR VPWR _1742_/Y sky130_fd_sc_hd__a22oi_1
X_1673_ _0996_/D _2154_/Q _2139_/Q VGND VGND VPWR VPWR _1673_/X sky130_fd_sc_hd__a21o_1
XFILLER_38_221 VGND VGND VPWR VPWR sky130_fd_sc_hd__fill_1
X_2225_ _2230_/CLK _2225_/D VGND VGND VPWR VPWR _2225_/Q sky130_fd_sc_hd__dfxtp_1
XFILLER_26_29 VGND VGND VPWR VPWR sky130_fd_sc_hd__decap_3
XPHY_EDGE_ROW_5_Right_5 VGND VGND VPWR VPWR sky130_fd_sc_hd__decap_3
X_2156_ _2161_/CLK _2156_/D wire75/X VGND VGND VPWR VPWR _2156_/Q sky130_fd_sc_hd__dfstp_2
X_2087_ clkload8/A _2087_/D load_slew70/X VGND VGND VPWR VPWR _2087_/Q sky130_fd_sc_hd__dfrtp_1
X_1107_ _2045_/Q _1282_/A2 _1105_/Y _1106_/Y VGND VGND VPWR VPWR _2174_/D sky130_fd_sc_hd__o2bb2ai_1
X_1038_ _1035_/A _1025_/C _1035_/D _1037_/Y VGND VGND VPWR VPWR _1038_/Y sky130_fd_sc_hd__a31oi_1
XTAP_TAPCELL_ROW_8_169 VGND VPWR sky130_fd_sc_hd__tapvpwrvgnd_1
XFILLER_44_213 VGND VGND VPWR VPWR sky130_fd_sc_hd__fill_2
XFILLER_12_110 VGND VGND VPWR VPWR sky130_fd_sc_hd__decap_4
XFILLER_16_73 VGND VGND VPWR VPWR sky130_fd_sc_hd__decap_4
X_2010_ _2219_/CLK _2010_/D _2050_/SET_B VGND VGND VPWR VPWR _2010_/Q sky130_fd_sc_hd__dfstp_2
X_1725_ _2119_/Q wire96/X wire94/X _2111_/Q VGND VGND VPWR VPWR _1725_/Y sky130_fd_sc_hd__a22oi_1
X_1656_ _1656_/A _1656_/B _1656_/C VGND VGND VPWR VPWR _1656_/Y sky130_fd_sc_hd__nor3_1
X_1587_ _1587_/A _1627_/B _1587_/C VGND VGND VPWR VPWR _1587_/Y sky130_fd_sc_hd__nor3_1
X_2208_ _2208_/CLK _2208_/D VGND VGND VPWR VPWR _2208_/Q sky130_fd_sc_hd__dfxtp_1
X_2139_ _2161_/CLK _2139_/D fanout76/X VGND VGND VPWR VPWR _2139_/Q sky130_fd_sc_hd__dfstp_2
XFILLER_41_205 VGND VGND VPWR VPWR sky130_fd_sc_hd__decap_3
XPHY_EDGE_ROW_36_Left_98 VGND VGND VPWR VPWR sky130_fd_sc_hd__decap_3
XTAP_TAPCELL_ROW_4_150 VGND VPWR sky130_fd_sc_hd__tapvpwrvgnd_1
XFILLER_17_257 VGND VGND VPWR VPWR sky130_fd_sc_hd__decap_3
XFILLER_4_194 VGND VGND VPWR VPWR sky130_fd_sc_hd__fill_2
XFILLER_4_65 VGND VGND VPWR VPWR sky130_fd_sc_hd__fill_1
X_1510_ _1894_/Q _1617_/B _1509_/Y VGND VGND VPWR VPWR _1511_/C sky130_fd_sc_hd__a21oi_1
X_1441_ _1639_/A _1639_/B _1936_/Q _2069_/Q _1457_/B2 VGND VGND VPWR VPWR _1441_/X
+ sky130_fd_sc_hd__o32a_1
X_1372_ _1450_/A3 _1370_/X _1371_/Y VGND VGND VPWR VPWR _1935_/D sky130_fd_sc_hd__a21oi_1
X_1708_ _2164_/Q _2165_/Q _2166_/Q _1989_/Q VGND VGND VPWR VPWR _1708_/X sky130_fd_sc_hd__a31o_1
XFILLER_48_27 VGND VGND VPWR VPWR sky130_fd_sc_hd__fill_1
X_1639_ _1639_/A _1639_/B _1639_/C VGND VGND VPWR VPWR _1922_/D sky130_fd_sc_hd__nor3_1
Xfanout20 _0988_/X VGND VGND VPWR VPWR _1556_/B1 sky130_fd_sc_hd__clkdlybuf4s50_1
Xfanout64 wire68/X VGND VGND VPWR VPWR fanout64/X sky130_fd_sc_hd__clkdlybuf4s50_1
XFILLER_38_71 VGND VGND VPWR VPWR sky130_fd_sc_hd__decap_6
X_1990_ clkload9/A _1990_/D fanout77/X VGND VGND VPWR VPWR _1990_/Q sky130_fd_sc_hd__dfrtp_1
XFILLER_9_264 VGND VGND VPWR VPWR sky130_fd_sc_hd__decap_3
Xclkload12 _2208_/CLK VGND VGND VPWR VPWR clkload12/X sky130_fd_sc_hd__clkbuf_1
X_1424_ _1424_/A _1424_/B _1424_/C VGND VGND VPWR VPWR _1424_/X sky130_fd_sc_hd__xnor3_1
X_1355_ _1932_/Q _1941_/Q VGND VGND VPWR VPWR _1358_/A sky130_fd_sc_hd__nand2_1
X_1286_ _1216_/A _1284_/X _1285_/Y VGND VGND VPWR VPWR _1286_/Y sky130_fd_sc_hd__a21oi_1
XTAP_TAPCELL_ROW_21_236 VGND VPWR sky130_fd_sc_hd__tapvpwrvgnd_1
Xclkload6 clkload6/A VGND VGND VPWR VPWR clkload6/X sky130_fd_sc_hd__clkbuf_1
Xclkbuf_leaf_15_dclk clkbuf_leaf_2_dclk/A VGND VGND VPWR VPWR clkload5/A sky130_fd_sc_hd__clkbuf_16
Xfanout210 _1928_/Q VGND VGND VPWR VPWR _1016_/A sky130_fd_sc_hd__clkdlybuf4s50_1
XFILLER_37_127 VGND VGND VPWR VPWR sky130_fd_sc_hd__decap_3
XTAP_TAPCELL_ROW_35_306 VGND VPWR sky130_fd_sc_hd__tapvpwrvgnd_1
X_1140_ _2197_/Q _1140_/B _1143_/C VGND VGND VPWR VPWR _1140_/X sky130_fd_sc_hd__xnor3_1
X_1071_ _1629_/A _1629_/B _1071_/C VGND VGND VPWR VPWR _1071_/Y sky130_fd_sc_hd__nor3_1
XPHY_EDGE_ROW_23_Left_85 VGND VGND VPWR VPWR sky130_fd_sc_hd__decap_3
X_1973_ clkload9/A _1973_/D fanout73/X VGND VGND VPWR VPWR _1973_/Q sky130_fd_sc_hd__dfstp_2
X_1407_ _2090_/Q _1451_/B2 _1456_/B1 _2074_/Q VGND VGND VPWR VPWR _1407_/Y sky130_fd_sc_hd__o22ai_1
X_1338_ _2184_/Q _2168_/Q _1362_/S VGND VGND VPWR VPWR _1340_/B sky130_fd_sc_hd__mux2i_1
X_1269_ _2171_/Q _1269_/B _1274_/B VGND VGND VPWR VPWR _1269_/X sky130_fd_sc_hd__xor3_1
XFILLER_3_215 VGND VGND VPWR VPWR sky130_fd_sc_hd__fill_2
XFILLER_3_248 VGND VGND VPWR VPWR sky130_fd_sc_hd__decap_4
XFILLER_42_141 VGND VGND VPWR VPWR sky130_fd_sc_hd__fill_2
XTAP_TAPCELL_ROW_40_331 VGND VPWR sky130_fd_sc_hd__tapvpwrvgnd_1
XFILLER_2_270 VGND VGND VPWR VPWR sky130_fd_sc_hd__fill_1
X_2172_ _2219_/CLK _2172_/D VGND VGND VPWR VPWR _2172_/Q sky130_fd_sc_hd__dfxtp_1
X_1123_ _2211_/Q _2182_/Q VGND VGND VPWR VPWR _1130_/B sky130_fd_sc_hd__xor2_1
X_1054_ _1054_/A _1054_/B _1054_/C VGND VGND VPWR VPWR _1057_/A sky130_fd_sc_hd__nand3_1
X_1956_ clkload1/A _1956_/D _1959_/DE VGND VGND VPWR VPWR _1956_/Q sky130_fd_sc_hd__edfxtp_1
X_1887_ _2114_/Q _1911_/Q _1887_/S VGND VGND VPWR VPWR _2114_/D sky130_fd_sc_hd__mux2_1
XFILLER_0_229 VGND VGND VPWR VPWR sky130_fd_sc_hd__fill_1
XTAP_TAPCELL_ROW_54_401 VGND VPWR sky130_fd_sc_hd__tapvpwrvgnd_1
XFILLER_24_141 VGND VGND VPWR VPWR sky130_fd_sc_hd__decap_3
Xmax_cap50 _1694_/S VGND VGND VPWR VPWR _1698_/S sky130_fd_sc_hd__clkbuf_2
X_1810_ _2045_/Q _1820_/A0 wire33/A VGND VGND VPWR VPWR _2045_/D sky130_fd_sc_hd__mux2_1
X_1741_ _1995_/Q _1747_/B VGND VGND VPWR VPWR _1741_/Y sky130_fd_sc_hd__nor2_1
X_1672_ _1820_/A0 _1984_/Q _2163_/D VGND VGND VPWR VPWR _1969_/D sky130_fd_sc_hd__mux2_1
X_2224_ _2224_/CLK _2224_/D VGND VGND VPWR VPWR _2224_/Q sky130_fd_sc_hd__dfxtp_1
X_2155_ _2221_/CLK input4/X fanout88/X VGND VGND VPWR VPWR _2155_/Q sky130_fd_sc_hd__dfstp_2
X_1106_ _1216_/A _1104_/X _1285_/B1 VGND VGND VPWR VPWR _1106_/Y sky130_fd_sc_hd__o21ai_0
X_2086_ clkload8/A _2086_/D fanout71/X VGND VGND VPWR VPWR _2086_/Q sky130_fd_sc_hd__dfrtp_1
X_1037_ _1017_/B _1022_/B _1009_/B _1016_/D _1652_/C VGND VGND VPWR VPWR _1037_/Y
+ sky130_fd_sc_hd__a221oi_1
XFILLER_21_166 VGND VGND VPWR VPWR sky130_fd_sc_hd__fill_2
X_1939_ clkload1/A _1939_/D _1955_/DE VGND VGND VPWR VPWR _1939_/Q sky130_fd_sc_hd__edfxtp_1
XPHY_EDGE_ROW_10_Left_72 VGND VGND VPWR VPWR sky130_fd_sc_hd__decap_3
XFILLER_16_85 VGND VGND VPWR VPWR sky130_fd_sc_hd__decap_6
XPHY_EDGE_ROW_11_Right_11 VGND VGND VPWR VPWR sky130_fd_sc_hd__decap_3
XPHY_EDGE_ROW_20_Right_20 VGND VGND VPWR VPWR sky130_fd_sc_hd__decap_3
XFILLER_35_214 VGND VGND VPWR VPWR sky130_fd_sc_hd__fill_1
XFILLER_35_225 VGND VGND VPWR VPWR sky130_fd_sc_hd__decap_3
XTAP_TAPCELL_ROW_13_194 VGND VPWR sky130_fd_sc_hd__tapvpwrvgnd_1
X_1724_ _1747_/B _1990_/Q _1723_/Y _1720_/Y VGND VGND VPWR VPWR _1990_/D sky130_fd_sc_hd__a2bb2oi_1
X_1655_ _1926_/Q fanout8/X _1654_/X _1641_/Y _1659_/C1 VGND VGND VPWR VPWR _1926_/D
+ sky130_fd_sc_hd__o221a_1
X_1586_ _1934_/Q _1625_/A VGND VGND VPWR VPWR _1587_/A sky130_fd_sc_hd__nor2b_1
X_2207_ _2223_/CLK _2207_/D VGND VGND VPWR VPWR _2207_/Q sky130_fd_sc_hd__dfxtp_1
X_2138_ _2208_/CLK _2138_/D fanout82/X VGND VGND VPWR VPWR _2138_/Q sky130_fd_sc_hd__dfrtp_1
X_2069_ clkload2/A _2069_/D fanout71/X VGND VGND VPWR VPWR _2069_/Q sky130_fd_sc_hd__dfrtp_1
XTAP_TAPCELL_ROW_4_151 VGND VPWR sky130_fd_sc_hd__tapvpwrvgnd_1
XFILLER_17_225 VGND VGND VPWR VPWR sky130_fd_sc_hd__decap_6
XFILLER_27_95 VGND VGND VPWR VPWR sky130_fd_sc_hd__fill_1
XTAP_TAPCELL_ROW_27_264 VGND VPWR sky130_fd_sc_hd__tapvpwrvgnd_1
X_1440_ _1440_/A1 _2084_/Q _1495_/B1 _1439_/X VGND VGND VPWR VPWR _1951_/D sky130_fd_sc_hd__o31a_1
X_1371_ _2084_/Q _1457_/B2 _1456_/B1 _2068_/Q VGND VGND VPWR VPWR _1371_/Y sky130_fd_sc_hd__o22ai_1
XTAP_TAPCELL_ROW_18_220 VGND VPWR sky130_fd_sc_hd__tapvpwrvgnd_1
X_1707_ _2156_/Q _2157_/Q _2158_/Q _1706_/X VGND VGND VPWR VPWR _1988_/D sky130_fd_sc_hd__o31a_1
X_1638_ _1922_/Q _1637_/B _1637_/Y VGND VGND VPWR VPWR _1639_/C sky130_fd_sc_hd__a21oi_1
X_1569_ _1609_/A _1609_/B _1569_/C VGND VGND VPWR VPWR _1908_/D sky130_fd_sc_hd__nor3_1
Xfanout21 _0967_/X VGND VGND VPWR VPWR _1958_/DE sky130_fd_sc_hd__clkdlybuf4s50_1
Xfanout54 fanout63/X VGND VGND VPWR VPWR fanout54/X sky130_fd_sc_hd__clkdlybuf4s50_1
Xfanout76 fanout77/X VGND VGND VPWR VPWR fanout76/X sky130_fd_sc_hd__clkdlybuf4s50_1
Xfanout87 fanout88/X VGND VGND VPWR VPWR fanout87/X sky130_fd_sc_hd__clkdlybuf4s50_1
XFILLER_49_169 VGND VGND VPWR VPWR sky130_fd_sc_hd__fill_2
Xclkbuf_leaf_0_dclk clkbuf_leaf_2_dclk/A VGND VGND VPWR VPWR clkload0/A sky130_fd_sc_hd__clkbuf_16
XFILLER_13_250 VGND VGND VPWR VPWR sky130_fd_sc_hd__fill_1
Xclkload13 _2224_/CLK VGND VGND VPWR VPWR clkload13/X sky130_fd_sc_hd__clkbuf_1
X_1423_ _1942_/Q _1960_/Q VGND VGND VPWR VPWR _1424_/C sky130_fd_sc_hd__xor2_1
X_1354_ _0983_/B _1352_/X _1353_/Y VGND VGND VPWR VPWR _1932_/D sky130_fd_sc_hd__a21oi_1
X_1285_ _1216_/A _2206_/Q _1285_/B1 VGND VGND VPWR VPWR _1285_/Y sky130_fd_sc_hd__o21ai_0
XTAP_TAPCELL_ROW_21_237 VGND VPWR sky130_fd_sc_hd__tapvpwrvgnd_1
Xclkload7 clkload7/A VGND VGND VPWR VPWR clkload7/X sky130_fd_sc_hd__clkbuf_8
Xfanout200 _1380_/S VGND VGND VPWR VPWR _1344_/S sky130_fd_sc_hd__clkdlybuf4s50_1
Xfanout211 _1926_/Q VGND VGND VPWR VPWR _1656_/B sky130_fd_sc_hd__clkdlybuf4s50_1
XFILLER_10_253 VGND VGND VPWR VPWR sky130_fd_sc_hd__fill_2
XTAP_TAPCELL_ROW_35_307 VGND VPWR sky130_fd_sc_hd__tapvpwrvgnd_1
X_1070_ _2215_/Q _1248_/B VGND VGND VPWR VPWR _1071_/C sky130_fd_sc_hd__nor2b_1
X_1972_ clkload9/A _1972_/D fanout73/X VGND VGND VPWR VPWR _1972_/Q sky130_fd_sc_hd__dfstp_2
XPHY_EDGE_ROW_49_Right_49 VGND VGND VPWR VPWR sky130_fd_sc_hd__decap_3
XFILLER_28_139 VGND VGND VPWR VPWR sky130_fd_sc_hd__fill_1
XPHY_EDGE_ROW_58_Right_58 VGND VGND VPWR VPWR sky130_fd_sc_hd__decap_3
X_1406_ _1406_/A _1406_/B _1406_/C VGND VGND VPWR VPWR _1406_/X sky130_fd_sc_hd__xnor3_1
X_1337_ _1929_/Q _1938_/Q VGND VGND VPWR VPWR _1340_/A sky130_fd_sc_hd__nand2_1
X_1268_ _2188_/Q _2223_/Q VGND VGND VPWR VPWR _1274_/B sky130_fd_sc_hd__xor2_1
X_1199_ _1362_/S _2184_/Q _1198_/Y _1329_/A2 VGND VGND VPWR VPWR _1199_/X sky130_fd_sc_hd__a211o_1
XFILLER_10_43 VGND VGND VPWR VPWR sky130_fd_sc_hd__fill_1
XTAP_TAPCELL_ROW_40_332 VGND VPWR sky130_fd_sc_hd__tapvpwrvgnd_1
X_2171_ _2219_/CLK _2171_/D VGND VGND VPWR VPWR _2171_/Q sky130_fd_sc_hd__dfxtp_1
X_1122_ _1297_/A2 _1121_/Y _1118_/Y VGND VGND VPWR VPWR _2177_/D sky130_fd_sc_hd__o21ai_0
XPHY_EDGE_ROW_38_Left_100 VGND VGND VPWR VPWR sky130_fd_sc_hd__decap_3
X_1053_ _1025_/C _1035_/D _1025_/B _1045_/Y VGND VGND VPWR VPWR _1054_/C sky130_fd_sc_hd__a31oi_1
X_1955_ clkload1/A _1955_/D _1955_/DE VGND VGND VPWR VPWR _1955_/Q sky130_fd_sc_hd__edfxtp_1
X_1886_ _2113_/Q _1910_/Q _1887_/S VGND VGND VPWR VPWR _2113_/D sky130_fd_sc_hd__mux2_1
XTAP_TAPCELL_ROW_54_402 VGND VPWR sky130_fd_sc_hd__tapvpwrvgnd_1
XFILLER_24_197 VGND VGND VPWR VPWR sky130_fd_sc_hd__fill_1
XFILLER_46_83 VGND VGND VPWR VPWR sky130_fd_sc_hd__fill_1
Xmax_cap95 wire96/X VGND VGND VPWR VPWR _1746_/A2 sky130_fd_sc_hd__clkbuf_2
Xmax_cap51 _0995_/Y VGND VGND VPWR VPWR _1694_/S sky130_fd_sc_hd__clkbuf_2
Xmax_cap40 _1757_/S VGND VGND VPWR VPWR wire39/A sky130_fd_sc_hd__clkbuf_2
XFILLER_7_55 VGND VGND VPWR VPWR sky130_fd_sc_hd__fill_1
X_1740_ _1747_/B _1738_/Y _1739_/Y _1737_/Y VGND VGND VPWR VPWR _1994_/D sky130_fd_sc_hd__a31oi_1
X_1671_ _1819_/A0 _1983_/Q _2163_/D VGND VGND VPWR VPWR _1968_/D sky130_fd_sc_hd__mux2_1
XFILLER_30_3 VGND VGND VPWR VPWR sky130_fd_sc_hd__fill_2
X_2223_ _2223_/CLK _2223_/D VGND VGND VPWR VPWR _2223_/Q sky130_fd_sc_hd__dfxtp_1
X_2154_ _2161_/CLK _2154_/D wire75/X VGND VGND VPWR VPWR _2154_/Q sky130_fd_sc_hd__dfstp_2
X_2085_ clkload2/A _2085_/D fanout71/X VGND VGND VPWR VPWR _2085_/Q sky130_fd_sc_hd__dfrtp_1
X_1105_ _2222_/Q _1216_/A VGND VGND VPWR VPWR _1105_/Y sky130_fd_sc_hd__nor2b_1
X_1036_ _1035_/D _1035_/A _1035_/B _1042_/B1 _1032_/Y VGND VGND VPWR VPWR _1050_/C
+ sky130_fd_sc_hd__a41oi_1
X_1938_ clkload8/A _1938_/D _1954_/DE VGND VGND VPWR VPWR _1938_/Q sky130_fd_sc_hd__edfxtp_1
X_1869_ _2096_/Q hold269/X _1882_/S VGND VGND VPWR VPWR _2096_/D sky130_fd_sc_hd__mux2_1
XFILLER_32_85 VGND VGND VPWR VPWR sky130_fd_sc_hd__fill_2
XTAP_TAPCELL_ROW_13_195 VGND VPWR sky130_fd_sc_hd__tapvpwrvgnd_1
X_1723_ _2102_/Q wire98/A wire94/A _2110_/Q _1722_/Y VGND VGND VPWR VPWR _1723_/Y
+ sky130_fd_sc_hd__a221oi_1
X_1654_ _1654_/A _1654_/B VGND VGND VPWR VPWR _1654_/X sky130_fd_sc_hd__xor2_1
X_2206_ _2224_/CLK _2206_/D VGND VGND VPWR VPWR _2206_/Q sky130_fd_sc_hd__dfxtp_1
X_1585_ _1625_/A _1364_/X VGND VGND VPWR VPWR _1587_/C sky130_fd_sc_hd__nor2b_1
XFILLER_26_204 VGND VGND VPWR VPWR sky130_fd_sc_hd__fill_1
XFILLER_26_226 VGND VGND VPWR VPWR sky130_fd_sc_hd__fill_1
XFILLER_34_270 VGND VGND VPWR VPWR sky130_fd_sc_hd__decap_4
XFILLER_41_229 VGND VGND VPWR VPWR sky130_fd_sc_hd__decap_3
X_1019_ wire46/X _1044_/A _1015_/A _1015_/B VGND VGND VPWR VPWR _1031_/C sky130_fd_sc_hd__o211a_1
X_2137_ _2166_/CLK _2137_/D fanout81/X VGND VGND VPWR VPWR _2137_/Q sky130_fd_sc_hd__dfrtp_1
X_2068_ clkload5/A _2068_/D fanout59/A VGND VGND VPWR VPWR _2068_/Q sky130_fd_sc_hd__dfrtp_1
XFILLER_34_281 VGND VGND VPWR VPWR sky130_fd_sc_hd__decap_4
XTAP_TAPCELL_ROW_4_152 VGND VPWR sky130_fd_sc_hd__tapvpwrvgnd_1
XFILLER_25_281 VGND VGND VPWR VPWR sky130_fd_sc_hd__decap_4
XFILLER_43_73 VGND VGND VPWR VPWR sky130_fd_sc_hd__decap_3
XTAP_TAPCELL_ROW_27_265 VGND VPWR sky130_fd_sc_hd__tapvpwrvgnd_1
XFILLER_4_23 VGND VGND VPWR VPWR sky130_fd_sc_hd__fill_1
X_1370_ _1370_/A _1370_/B _1370_/C VGND VGND VPWR VPWR _1370_/X sky130_fd_sc_hd__xnor3_1
XTAP_TAPCELL_ROW_18_221 VGND VPWR sky130_fd_sc_hd__tapvpwrvgnd_1
X_1706_ _2156_/Q _2157_/Q _2158_/Q _1988_/Q VGND VGND VPWR VPWR _1706_/X sky130_fd_sc_hd__a31o_1
X_1637_ _1637_/A _1637_/B _1637_/C VGND VGND VPWR VPWR _1637_/Y sky130_fd_sc_hd__nor3_1
X_1568_ _1908_/Q _1607_/B _1567_/Y VGND VGND VPWR VPWR _1569_/C sky130_fd_sc_hd__a21oi_1
X_1499_ _1609_/A _1609_/B _1499_/C VGND VGND VPWR VPWR _1891_/D sky130_fd_sc_hd__nor3_1
XTAP_TAPCELL_ROW_32_290 VGND VPWR sky130_fd_sc_hd__tapvpwrvgnd_1
Xfanout66 wire68/A VGND VGND VPWR VPWR fanout66/X sky130_fd_sc_hd__clkdlybuf4s50_1
Xfanout77 fanout81/X VGND VGND VPWR VPWR fanout77/X sky130_fd_sc_hd__clkdlybuf4s50_1
Xfanout88 fanout89/X VGND VGND VPWR VPWR fanout88/X sky130_fd_sc_hd__clkdlybuf4s50_1
XFILLER_8_3 VGND VGND VPWR VPWR sky130_fd_sc_hd__fill_1
XFILLER_54_83 VGND VGND VPWR VPWR sky130_fd_sc_hd__fill_1
XFILLER_54_94 VGND VGND VPWR VPWR sky130_fd_sc_hd__fill_2
XFILLER_9_211 VGND VGND VPWR VPWR sky130_fd_sc_hd__decap_8
Xclkload14 _2221_/CLK VGND VGND VPWR VPWR clkload14/X sky130_fd_sc_hd__clkbuf_1
X_1422_ _2198_/Q _2182_/Q _1422_/S VGND VGND VPWR VPWR _1424_/B sky130_fd_sc_hd__mux2i_1
X_1353_ _2081_/Q _1451_/B2 _1456_/B1 _2065_/Q VGND VGND VPWR VPWR _1353_/Y sky130_fd_sc_hd__o22ai_1
X_1284_ _2174_/Q _1284_/B _1289_/B VGND VGND VPWR VPWR _1284_/X sky130_fd_sc_hd__xor3_1
XTAP_TAPCELL_ROW_46_360 VGND VPWR sky130_fd_sc_hd__tapvpwrvgnd_1
XTAP_TAPCELL_ROW_21_238 VGND VPWR sky130_fd_sc_hd__tapvpwrvgnd_1
X_0999_ _1006_/B _1022_/C _1654_/A VGND VGND VPWR VPWR _0999_/Y sky130_fd_sc_hd__a21oi_1
Xclkload8 clkload8/A VGND VGND VPWR VPWR clkload8/X sky130_fd_sc_hd__clkbuf_1
Xfanout201 _1380_/S VGND VGND VPWR VPWR _1362_/S sky130_fd_sc_hd__clkdlybuf4s50_1
Xfanout212 _1925_/Q VGND VGND VPWR VPWR _1008_/B sky130_fd_sc_hd__clkdlybuf4s50_1
XFILLER_10_232 VGND VGND VPWR VPWR sky130_fd_sc_hd__decap_4
XFILLER_6_258 VGND VGND VPWR VPWR sky130_fd_sc_hd__decap_8
XFILLER_1_24 VGND VGND VPWR VPWR sky130_fd_sc_hd__decap_4
XFILLER_27_9 VGND VGND VPWR VPWR sky130_fd_sc_hd__fill_2
XTAP_TAPCELL_ROW_35_308 VGND VPWR sky130_fd_sc_hd__tapvpwrvgnd_1
XFILLER_60_3 VGND VGND VPWR VPWR sky130_fd_sc_hd__fill_1
X_1971_ clkload9/A _1971_/D fanout73/X VGND VGND VPWR VPWR _1971_/Q sky130_fd_sc_hd__dfstp_2
X_1405_ _1939_/Q _1957_/Q VGND VGND VPWR VPWR _1406_/C sky130_fd_sc_hd__xor2_1
Xinput1 drst_n VGND VGND VPWR VPWR input1/X sky130_fd_sc_hd__buf_2
X_1336_ _1450_/A3 _1333_/X _1335_/Y VGND VGND VPWR VPWR _1929_/D sky130_fd_sc_hd__a21oi_1
X_1267_ hold268/X _1267_/A2 _1266_/Y VGND VGND VPWR VPWR _2186_/D sky130_fd_sc_hd__a21o_1
X_1198_ _1344_/S _2216_/Q VGND VGND VPWR VPWR _1198_/Y sky130_fd_sc_hd__nor2b_1
XFILLER_36_173 VGND VGND VPWR VPWR sky130_fd_sc_hd__decap_3
XFILLER_36_195 VGND VGND VPWR VPWR sky130_fd_sc_hd__fill_1
XFILLER_51_198 VGND VGND VPWR VPWR sky130_fd_sc_hd__fill_1
XFILLER_19_75 VGND VGND VPWR VPWR sky130_fd_sc_hd__fill_1
XTAP_TAPCELL_ROW_40_333 VGND VPWR sky130_fd_sc_hd__tapvpwrvgnd_1
XFILLER_2_283 VGND VGND VPWR VPWR sky130_fd_sc_hd__fill_2
X_2170_ _2219_/CLK _2170_/D VGND VGND VPWR VPWR _2170_/Q sky130_fd_sc_hd__dfxtp_1
X_1121_ _1120_/X _2225_/Q _1240_/A VGND VGND VPWR VPWR _1121_/Y sky130_fd_sc_hd__mux2i_1
X_1052_ _1052_/A _1052_/B _1052_/C VGND VGND VPWR VPWR _1247_/A sky130_fd_sc_hd__nand3_1
XFILLER_33_165 VGND VGND VPWR VPWR sky130_fd_sc_hd__decap_3
X_1954_ clkload8/A _1954_/D _1954_/DE VGND VGND VPWR VPWR _1954_/Q sky130_fd_sc_hd__edfxtp_1
X_1885_ _2112_/Q hold272/X _1885_/S VGND VGND VPWR VPWR _2112_/D sky130_fd_sc_hd__mux2_1
XFILLER_56_29 VGND VGND VPWR VPWR sky130_fd_sc_hd__fill_2
X_2145__216 VGND VGND VPWR VPWR _2145__216/HI _2145_/D sky130_fd_sc_hd__conb_1
XTAP_TAPCELL_ROW_54_403 VGND VPWR sky130_fd_sc_hd__tapvpwrvgnd_1
X_1319_ _2217_/Q _2198_/Q VGND VGND VPWR VPWR _1326_/B sky130_fd_sc_hd__xor2_1
XFILLER_24_165 VGND VGND VPWR VPWR sky130_fd_sc_hd__decap_3
Xmax_cap30 _1829_/S VGND VGND VPWR VPWR _1828_/S sky130_fd_sc_hd__buf_2
XFILLER_15_165 VGND VGND VPWR VPWR sky130_fd_sc_hd__decap_3
Xmax_cap41 wire42/X VGND VGND VPWR VPWR _1745_/B sky130_fd_sc_hd__clkbuf_2
X_1670_ _1818_/A0 _1982_/Q _2163_/D VGND VGND VPWR VPWR _1967_/D sky130_fd_sc_hd__mux2_1
X_2222_ _2224_/CLK _2222_/D VGND VGND VPWR VPWR _2222_/Q sky130_fd_sc_hd__dfxtp_1
XFILLER_38_257 VGND VGND VPWR VPWR sky130_fd_sc_hd__fill_1
XFILLER_53_238 VGND VGND VPWR VPWR sky130_fd_sc_hd__fill_2
X_2153_ _2219_/CLK _2153_/D input1/X VGND VGND VPWR VPWR _2153_/Q sky130_fd_sc_hd__dfrtp_1
X_2084_ clkload2/A _2084_/D fanout59/A VGND VGND VPWR VPWR _2084_/Q sky130_fd_sc_hd__dfrtp_1
X_1104_ _2190_/Q _1104_/B _1109_/B VGND VGND VPWR VPWR _1104_/X sky130_fd_sc_hd__xnor3_1
X_1035_ _1035_/A _1035_/B _1035_/C _1035_/D VGND VGND VPWR VPWR _1035_/Y sky130_fd_sc_hd__nand4_1
XFILLER_21_113 VGND VGND VPWR VPWR sky130_fd_sc_hd__fill_1
X_1937_ clkload2/A _1937_/D _1955_/DE VGND VGND VPWR VPWR _1937_/Q sky130_fd_sc_hd__edfxtp_1
X_1868_ _2095_/Q hold281/X _1882_/S VGND VGND VPWR VPWR _2095_/D sky130_fd_sc_hd__mux2_1
X_1799_ _0969_/D _2036_/Q wire12/X VGND VGND VPWR VPWR _2036_/D sky130_fd_sc_hd__mux2_1
XPHY_EDGE_ROW_57_Left_119 VGND VGND VPWR VPWR sky130_fd_sc_hd__decap_3
XPHY_EDGE_ROW_9_Right_9 VGND VGND VPWR VPWR sky130_fd_sc_hd__decap_3
XTAP_TAPCELL_ROW_13_196 VGND VPWR sky130_fd_sc_hd__tapvpwrvgnd_1
X_1722_ _2094_/Q wire42/X _1721_/Y _0972_/C VGND VGND VPWR VPWR _1722_/Y sky130_fd_sc_hd__o2bb2ai_1
X_1653_ _1656_/A _0965_/C _1652_/Y VGND VGND VPWR VPWR _1654_/B sky130_fd_sc_hd__a21oi_1
X_1584_ _1624_/A _1624_/B _1584_/C VGND VGND VPWR VPWR _1911_/D sky130_fd_sc_hd__nor3_1
X_2205_ _2221_/CLK _2205_/D VGND VGND VPWR VPWR _2205_/Q sky130_fd_sc_hd__dfxtp_1
X_1018_ _1022_/C _1017_/B _1022_/B _1044_/A VGND VGND VPWR VPWR _1018_/Y sky130_fd_sc_hd__a31oi_1
X_2136_ _2166_/CLK _2136_/D fanout81/X VGND VGND VPWR VPWR _2136_/Q sky130_fd_sc_hd__dfrtp_1
X_2067_ clkload7/A _2067_/D load_slew58/X VGND VGND VPWR VPWR _2067_/Q sky130_fd_sc_hd__dfrtp_1
XTAP_TAPCELL_ROW_4_153 VGND VPWR sky130_fd_sc_hd__tapvpwrvgnd_1
XTAP_TAPCELL_ROW_27_266 VGND VPWR sky130_fd_sc_hd__tapvpwrvgnd_1
XFILLER_4_131 VGND VGND VPWR VPWR sky130_fd_sc_hd__decap_3
XTAP_TAPCELL_ROW_18_222 VGND VPWR sky130_fd_sc_hd__tapvpwrvgnd_1
X_1705_ _0995_/Y _1704_/X _0996_/C _1699_/X _1987_/Q VGND VGND VPWR VPWR _1987_/D
+ sky130_fd_sc_hd__a32o_1
X_1636_ _1944_/Q _1635_/A VGND VGND VPWR VPWR _1637_/A sky130_fd_sc_hd__nor2b_1
X_1567_ _1567_/A _1607_/B _1567_/C VGND VGND VPWR VPWR _1567_/Y sky130_fd_sc_hd__nor3_1
XFILLER_58_149 VGND VGND VPWR VPWR sky130_fd_sc_hd__fill_1
XTAP_TAPCELL_ROW_1_134 VGND VPWR sky130_fd_sc_hd__tapvpwrvgnd_1
X_2119_ clkload9/A _2119_/D fanout69/A VGND VGND VPWR VPWR _2119_/Q sky130_fd_sc_hd__dfrtp_1
X_1498_ _1891_/Q _1562_/B _1497_/Y VGND VGND VPWR VPWR _1499_/C sky130_fd_sc_hd__a21oi_1
XFILLER_14_219 VGND VGND VPWR VPWR sky130_fd_sc_hd__fill_1
Xfanout23 _0967_/X VGND VGND VPWR VPWR _1959_/DE sky130_fd_sc_hd__clkdlybuf4s50_1
Xfanout56 fanout63/X VGND VGND VPWR VPWR fanout56/X sky130_fd_sc_hd__clkdlybuf4s50_1
Xfanout67 fanout91/A VGND VGND VPWR VPWR wire68/A sky130_fd_sc_hd__clkdlybuf4s50_1
Xfanout78 fanout81/X VGND VGND VPWR VPWR fanout78/X sky130_fd_sc_hd__clkdlybuf4s50_1
Xfanout89 fanout91/X VGND VGND VPWR VPWR fanout89/X sky130_fd_sc_hd__clkdlybuf4s50_1
XTAP_TAPCELL_ROW_32_291 VGND VPWR sky130_fd_sc_hd__tapvpwrvgnd_1
XFILLER_1_101 VGND VGND VPWR VPWR sky130_fd_sc_hd__fill_2
XFILLER_9_256 VGND VGND VPWR VPWR sky130_fd_sc_hd__decap_8
Xclkload15 _2219_/CLK VGND VGND VPWR VPWR clkload15/X sky130_fd_sc_hd__clkbuf_8
X_1421_ _1943_/Q _1936_/Q VGND VGND VPWR VPWR _1424_/A sky130_fd_sc_hd__nand2_1
XFILLER_48_193 VGND VGND VPWR VPWR sky130_fd_sc_hd__decap_3
X_1352_ _1352_/A _1352_/B _1352_/C VGND VGND VPWR VPWR _1352_/X sky130_fd_sc_hd__xnor3_1
X_1283_ _2191_/Q _2226_/Q VGND VGND VPWR VPWR _1289_/B sky130_fd_sc_hd__xor2_1
XTAP_TAPCELL_ROW_46_361 VGND VPWR sky130_fd_sc_hd__tapvpwrvgnd_1
X_0998_ _1008_/B _1022_/C VGND VGND VPWR VPWR _1016_/D sky130_fd_sc_hd__nand2b_1
Xclkload9 clkload9/A VGND VGND VPWR VPWR clkload9/X sky130_fd_sc_hd__clkbuf_8
Xfanout202 _1186_/A VGND VGND VPWR VPWR _1380_/S sky130_fd_sc_hd__clkdlybuf4s50_1
Xfanout213 _1924_/Q VGND VGND VPWR VPWR _1652_/B sky130_fd_sc_hd__clkdlybuf4s50_1
X_1619_ _1634_/A _1634_/B _1619_/C VGND VGND VPWR VPWR _1918_/D sky130_fd_sc_hd__nor3_1
XFILLER_54_174 VGND VGND VPWR VPWR sky130_fd_sc_hd__fill_1
XFILLER_10_277 VGND VGND VPWR VPWR sky130_fd_sc_hd__decap_8
X_1970_ clkload9/A _1970_/D fanout73/X VGND VGND VPWR VPWR _1970_/Q sky130_fd_sc_hd__dfstp_2
XFILLER_5_281 VGND VGND VPWR VPWR sky130_fd_sc_hd__decap_4
X_1404_ _2195_/Q _2179_/Q _1410_/S VGND VGND VPWR VPWR _1406_/B sky130_fd_sc_hd__mux2i_1
X_1335_ _2078_/Q _1448_/A2 _1448_/B1 _2062_/Q VGND VGND VPWR VPWR _1335_/Y sky130_fd_sc_hd__o22ai_1
Xinput2 duio_in[0] VGND VGND VPWR VPWR input2/X sky130_fd_sc_hd__buf_2
X_1266_ _1210_/A _1264_/X _1265_/Y VGND VGND VPWR VPWR _1266_/Y sky130_fd_sc_hd__a21oi_1
X_1197_ _2006_/Q _1310_/B1 _1196_/X VGND VGND VPWR VPWR _2199_/D sky130_fd_sc_hd__o21a_1
XFILLER_51_122 VGND VGND VPWR VPWR sky130_fd_sc_hd__fill_1
XFILLER_10_23 VGND VGND VPWR VPWR sky130_fd_sc_hd__fill_1
XFILLER_59_277 VGND VGND VPWR VPWR sky130_fd_sc_hd__decap_3
XFILLER_27_185 VGND VGND VPWR VPWR sky130_fd_sc_hd__decap_4
XPHY_EDGE_ROW_27_Left_89 VGND VGND VPWR VPWR sky130_fd_sc_hd__decap_3
XFILLER_18_141 VGND VGND VPWR VPWR sky130_fd_sc_hd__decap_4
XFILLER_33_111 VGND VGND VPWR VPWR sky130_fd_sc_hd__fill_1
X_1120_ _2193_/Q _1120_/B _1124_/B VGND VGND VPWR VPWR _1120_/X sky130_fd_sc_hd__xnor3_1
X_1051_ _1050_/A _1050_/B _1050_/C _1041_/X VGND VGND VPWR VPWR _1051_/Y sky130_fd_sc_hd__a31oi_1
X_1953_ clkload2/A _1953_/D _1954_/DE VGND VGND VPWR VPWR _1953_/Q sky130_fd_sc_hd__edfxtp_1
X_1884_ _2111_/Q _1908_/Q _1884_/S VGND VGND VPWR VPWR _2111_/D sky130_fd_sc_hd__mux2_1
X_1318_ _2059_/Q _1324_/A2 _1317_/X VGND VGND VPWR VPWR _2196_/D sky130_fd_sc_hd__a21o_1
X_1249_ _1248_/B _2199_/Q _1317_/C1 VGND VGND VPWR VPWR _1249_/Y sky130_fd_sc_hd__o21ai_0
XFILLER_21_88 VGND VGND VPWR VPWR sky130_fd_sc_hd__decap_4
XFILLER_47_225 VGND VGND VPWR VPWR sky130_fd_sc_hd__fill_2
Xmax_cap53 _0976_/Y VGND VGND VPWR VPWR _1490_/S sky130_fd_sc_hd__clkbuf_4
XFILLER_15_188 VGND VGND VPWR VPWR sky130_fd_sc_hd__decap_6
XTAP_TAPCELL_ROW_60_429 VGND VPWR sky130_fd_sc_hd__tapvpwrvgnd_1
XFILLER_16_3 VGND VGND VPWR VPWR sky130_fd_sc_hd__fill_2
X_2221_ _2221_/CLK _2221_/D VGND VGND VPWR VPWR _2221_/Q sky130_fd_sc_hd__dfxtp_1
X_2152_ _2219_/CLK _2152_/D input1/X VGND VGND VPWR VPWR _2152_/Q sky130_fd_sc_hd__dfrtp_1
X_2083_ clkload7/A _2083_/D load_slew58/X VGND VGND VPWR VPWR _2083_/Q sky130_fd_sc_hd__dfrtp_1
X_1103_ _2207_/Q _2178_/Q VGND VGND VPWR VPWR _1109_/B sky130_fd_sc_hd__xor2_1
X_1034_ _1927_/Q _1926_/Q _1016_/D _1928_/Q VGND VGND VPWR VPWR _1035_/C sky130_fd_sc_hd__o31ai_1
X_1936_ clkload2/A _1936_/D _1955_/DE VGND VGND VPWR VPWR _1936_/Q sky130_fd_sc_hd__edfxtp_1
X_1867_ _2094_/Q hold279/X _1884_/S VGND VGND VPWR VPWR _2094_/D sky130_fd_sc_hd__mux2_1
X_1798_ _0969_/A _2035_/Q wire12/X VGND VGND VPWR VPWR _2035_/D sky130_fd_sc_hd__mux2_1
XFILLER_20_191 VGND VGND VPWR VPWR sky130_fd_sc_hd__decap_4
Xclkbuf_leaf_3_dclk clkbuf_leaf_9_dclk/A VGND VGND VPWR VPWR clkload8/A sky130_fd_sc_hd__clkbuf_16
XTAP_TAPCELL_ROW_13_197 VGND VPWR sky130_fd_sc_hd__tapvpwrvgnd_1
X_1721_ _1721_/A _2143_/Q _1721_/C _1721_/D VGND VGND VPWR VPWR _1721_/Y sky130_fd_sc_hd__nand4_1
X_1652_ _1925_/Q _1652_/B _1652_/C _1656_/A VGND VGND VPWR VPWR _1652_/Y sky130_fd_sc_hd__nor4_1
X_1583_ _1911_/Q _1632_/B _1582_/Y VGND VGND VPWR VPWR _1584_/C sky130_fd_sc_hd__a21oi_1
X_2204_ _2221_/CLK _2204_/D VGND VGND VPWR VPWR _2204_/Q sky130_fd_sc_hd__dfxtp_1
X_2135_ _2166_/CLK _2135_/D fanout78/X VGND VGND VPWR VPWR _2135_/Q sky130_fd_sc_hd__dfrtp_1
XPHY_EDGE_ROW_14_Left_76 VGND VGND VPWR VPWR sky130_fd_sc_hd__decap_3
X_1017_ _1022_/C _1017_/B _1022_/B VGND VGND VPWR VPWR _1055_/C sky130_fd_sc_hd__nand3_1
X_2066_ clkload0/A _2066_/D _2145_/SET_B VGND VGND VPWR VPWR _2066_/Q sky130_fd_sc_hd__dfrtp_1
X_1919_ clkload6/A _1919_/D VGND VGND VPWR VPWR _1919_/Q sky130_fd_sc_hd__dfxtp_1
XTAP_TAPCELL_ROW_27_267 VGND VPWR sky130_fd_sc_hd__tapvpwrvgnd_1
XFILLER_43_53 VGND VGND VPWR VPWR sky130_fd_sc_hd__decap_3
XTAP_TAPCELL_ROW_18_223 VGND VPWR sky130_fd_sc_hd__tapvpwrvgnd_1
X_1704_ _1985_/Q _1986_/Q _1987_/Q VGND VGND VPWR VPWR _1704_/X sky130_fd_sc_hd__a21o_1
XFILLER_58_139 VGND VGND VPWR VPWR sky130_fd_sc_hd__fill_1
X_1635_ _1635_/A _1424_/X VGND VGND VPWR VPWR _1637_/C sky130_fd_sc_hd__nor2b_1
X_1566_ _1930_/Q _1635_/A VGND VGND VPWR VPWR _1567_/A sky130_fd_sc_hd__nor2b_1
X_1497_ _1600_/A _1333_/X _1496_/Y VGND VGND VPWR VPWR _1497_/Y sky130_fd_sc_hd__a21oi_1
XTAP_TAPCELL_ROW_1_135 VGND VPWR sky130_fd_sc_hd__tapvpwrvgnd_1
X_2118_ _2208_/CLK _2118_/D fanout77/X VGND VGND VPWR VPWR _2118_/Q sky130_fd_sc_hd__dfrtp_1
X_2049_ _2221_/CLK _2049_/D fanout89/X VGND VGND VPWR VPWR _2049_/Q sky130_fd_sc_hd__dfrtp_1
XFILLER_13_45 VGND VGND VPWR VPWR sky130_fd_sc_hd__fill_2
XTAP_TAPCELL_ROW_32_292 VGND VPWR sky130_fd_sc_hd__tapvpwrvgnd_1
Xfanout13 _1632_/B VGND VGND VPWR VPWR _1617_/B sky130_fd_sc_hd__clkdlybuf4s50_1
Xfanout24 _0967_/X VGND VGND VPWR VPWR _1960_/DE sky130_fd_sc_hd__clkdlybuf4s50_1
Xfanout57 fanout63/X VGND VGND VPWR VPWR fanout57/X sky130_fd_sc_hd__clkdlybuf4s50_1
XFILLER_38_42 VGND VGND VPWR VPWR sky130_fd_sc_hd__fill_2
XFILLER_13_242 VGND VGND VPWR VPWR sky130_fd_sc_hd__decap_8
XTAP_TAPCELL_ROW_15_204 VGND VPWR sky130_fd_sc_hd__tapvpwrvgnd_1
XFILLER_13_275 VGND VGND VPWR VPWR sky130_fd_sc_hd__decap_4
XFILLER_9_202 VGND VGND VPWR VPWR sky130_fd_sc_hd__fill_2
X_1420_ _1450_/A3 _1418_/X _1419_/Y VGND VGND VPWR VPWR _1943_/D sky130_fd_sc_hd__a21oi_1
X_1351_ _1930_/Q _1948_/Q VGND VGND VPWR VPWR _1352_/C sky130_fd_sc_hd__xor2_1
X_1282_ _2052_/Q _1282_/A2 _1281_/Y VGND VGND VPWR VPWR _2189_/D sky130_fd_sc_hd__a21o_1
XTAP_TAPCELL_ROW_46_362 VGND VPWR sky130_fd_sc_hd__tapvpwrvgnd_1
X_0997_ _1008_/B _1022_/C VGND VGND VPWR VPWR _0997_/Y sky130_fd_sc_hd__nor2b_1
X_1618_ _1918_/Q _1617_/B _1617_/Y VGND VGND VPWR VPWR _1619_/C sky130_fd_sc_hd__a21oi_1
Xfanout203 _1374_/S VGND VGND VPWR VPWR _1216_/A sky130_fd_sc_hd__clkdlybuf4s50_1
Xfanout214 _1924_/Q VGND VGND VPWR VPWR _1048_/C sky130_fd_sc_hd__clkdlybuf4s50_1
X_1549_ _1625_/A _1412_/X _1548_/Y VGND VGND VPWR VPWR _1549_/Y sky130_fd_sc_hd__a21oi_1
XFILLER_39_183 VGND VGND VPWR VPWR sky130_fd_sc_hd__fill_1
XFILLER_40_76 VGND VGND VPWR VPWR sky130_fd_sc_hd__decap_3
Xhold290 _1915_/Q VGND VGND VPWR VPWR hold290/X sky130_fd_sc_hd__dlygate4sd3_1
XFILLER_5_260 VGND VGND VPWR VPWR sky130_fd_sc_hd__decap_3
XPHY_EDGE_ROW_18_Right_18 VGND VGND VPWR VPWR sky130_fd_sc_hd__decap_3
X_1403_ _1940_/Q _1933_/Q VGND VGND VPWR VPWR _1406_/A sky130_fd_sc_hd__nand2_1
X_1334_ _1634_/A _1634_/B _1625_/A VGND VGND VPWR VPWR _1334_/Y sky130_fd_sc_hd__o21bai_1
X_1265_ _1210_/A _2202_/Q _1270_/B1 VGND VGND VPWR VPWR _1265_/Y sky130_fd_sc_hd__o21ai_0
XPHY_EDGE_ROW_27_Right_27 VGND VGND VPWR VPWR sky130_fd_sc_hd__decap_3
Xinput3 duio_in[1] VGND VGND VPWR VPWR input3/X sky130_fd_sc_hd__buf_2
X_1196_ _1331_/S _2183_/Q _1195_/Y _1324_/A2 VGND VGND VPWR VPWR _1196_/X sky130_fd_sc_hd__a211o_1
XFILLER_51_189 VGND VGND VPWR VPWR sky130_fd_sc_hd__fill_2
XPHY_EDGE_ROW_36_Right_36 VGND VGND VPWR VPWR sky130_fd_sc_hd__decap_3
XFILLER_35_10 VGND VGND VPWR VPWR sky130_fd_sc_hd__decap_4
XFILLER_35_43 VGND VGND VPWR VPWR sky130_fd_sc_hd__decap_4
XPHY_EDGE_ROW_45_Right_45 VGND VGND VPWR VPWR sky130_fd_sc_hd__decap_3
XPHY_EDGE_ROW_2_Left_64 VGND VGND VPWR VPWR sky130_fd_sc_hd__decap_3
XPHY_EDGE_ROW_54_Right_54 VGND VGND VPWR VPWR sky130_fd_sc_hd__decap_3
X_1050_ _1050_/A _1050_/B _1050_/C VGND VGND VPWR VPWR _1052_/C sky130_fd_sc_hd__nand3_1
X_1952_ clkload2/A _1952_/D _1954_/DE VGND VGND VPWR VPWR _1952_/Q sky130_fd_sc_hd__edfxtp_1
X_1883_ _2110_/Q hold267/X _1884_/S VGND VGND VPWR VPWR _2110_/D sky130_fd_sc_hd__mux2_1
X_1317_ _1248_/B _2212_/Q _1316_/Y _1315_/X _1317_/C1 VGND VGND VPWR VPWR _1317_/X
+ sky130_fd_sc_hd__o221a_1
X_1248_ _1248_/A _1248_/B VGND VGND VPWR VPWR _1248_/Y sky130_fd_sc_hd__nand2_1
X_1179_ _2032_/Q _1444_/A3 _1178_/X VGND VGND VPWR VPWR _2225_/D sky130_fd_sc_hd__o21a_1
XFILLER_15_101 VGND VGND VPWR VPWR sky130_fd_sc_hd__fill_1
XFILLER_55_281 VGND VGND VPWR VPWR sky130_fd_sc_hd__decap_4
Xmax_cap43 _1024_/Y VGND VGND VPWR VPWR _1035_/B sky130_fd_sc_hd__buf_1
Xmax_cap32 wire33/X VGND VGND VPWR VPWR _1805_/S sky130_fd_sc_hd__clkbuf_2
XFILLER_38_215 VGND VGND VPWR VPWR sky130_fd_sc_hd__decap_6
XFILLER_38_226 VGND VGND VPWR VPWR sky130_fd_sc_hd__decap_8
X_2220_ _2221_/CLK _2220_/D VGND VGND VPWR VPWR _2220_/Q sky130_fd_sc_hd__dfxtp_1
X_2151_ _2219_/CLK _2151_/D input1/X VGND VGND VPWR VPWR _2151_/Q sky130_fd_sc_hd__dfrtp_1
X_2082_ clkload0/A _2082_/D fanout56/X VGND VGND VPWR VPWR _2082_/Q sky130_fd_sc_hd__dfrtp_1
X_1102_ _1282_/A2 _1101_/Y _1098_/Y VGND VGND VPWR VPWR _2173_/D sky130_fd_sc_hd__o21ai_0
X_1033_ _1014_/B _1014_/A _1023_/X VGND VGND VPWR VPWR _1033_/Y sky130_fd_sc_hd__o21ai_0
X_1935_ clkload5/A _1935_/D _1958_/DE VGND VGND VPWR VPWR _1935_/Q sky130_fd_sc_hd__edfxtp_1
X_1866_ _0969_/C _2093_/Q _1866_/S VGND VGND VPWR VPWR _2093_/D sky130_fd_sc_hd__mux2_1
X_1797_ _0969_/B _2034_/Q wire12/X VGND VGND VPWR VPWR _2034_/D sky130_fd_sc_hd__mux2_1
XFILLER_29_248 VGND VGND VPWR VPWR sky130_fd_sc_hd__fill_1
XFILLER_37_281 VGND VGND VPWR VPWR sky130_fd_sc_hd__decap_4
XFILLER_32_44 VGND VGND VPWR VPWR sky130_fd_sc_hd__decap_4
XPHY_EDGE_ROW_0_Right_0 VGND VGND VPWR VPWR sky130_fd_sc_hd__decap_3
XFILLER_57_74 VGND VGND VPWR VPWR sky130_fd_sc_hd__fill_1
XFILLER_28_281 VGND VGND VPWR VPWR sky130_fd_sc_hd__decap_4
XFILLER_35_207 VGND VGND VPWR VPWR sky130_fd_sc_hd__decap_3
XTAP_TAPCELL_ROW_13_198 VGND VPWR sky130_fd_sc_hd__tapvpwrvgnd_1
X_1720_ _2118_/Q wire96/X _1747_/B VGND VGND VPWR VPWR _1720_/Y sky130_fd_sc_hd__a21boi_0
X_1651_ _1008_/B fanout8/X _1659_/C1 _1650_/Y VGND VGND VPWR VPWR _1925_/D sky130_fd_sc_hd__o211a_1
XFILLER_7_196 VGND VGND VPWR VPWR sky130_fd_sc_hd__fill_2
X_1582_ _1582_/A _1617_/B _1582_/C VGND VGND VPWR VPWR _1582_/Y sky130_fd_sc_hd__nor3_1
XFILLER_19_281 VGND VGND VPWR VPWR sky130_fd_sc_hd__decap_4
X_2203_ _2219_/CLK _2203_/D VGND VGND VPWR VPWR _2203_/Q sky130_fd_sc_hd__dfxtp_1
X_2134_ _2166_/CLK _2134_/D load_slew79/X VGND VGND VPWR VPWR _2134_/Q sky130_fd_sc_hd__dfrtp_1
X_2065_ clkload0/A _2065_/D fanout54/X VGND VGND VPWR VPWR _2065_/Q sky130_fd_sc_hd__dfrtp_1
X_1016_ _1016_/A _1927_/Q _1926_/Q _1016_/D VGND VGND VPWR VPWR wire46/A sky130_fd_sc_hd__nor4_1
X_1918_ clkload0/A _1918_/D VGND VGND VPWR VPWR _1918_/Q sky130_fd_sc_hd__dfxtp_1
X_1849_ _1858_/A _1858_/B wire98/A _1858_/D VGND VGND VPWR VPWR _1857_/S sky130_fd_sc_hd__nand4_1
XFILLER_17_207 VGND VGND VPWR VPWR sky130_fd_sc_hd__decap_8
XFILLER_25_240 VGND VGND VPWR VPWR sky130_fd_sc_hd__fill_2
XFILLER_27_44 VGND VGND VPWR VPWR sky130_fd_sc_hd__decap_3
XTAP_TAPCELL_ROW_27_268 VGND VPWR sky130_fd_sc_hd__tapvpwrvgnd_1
Xload_slew9 _1844_/S VGND VGND VPWR VPWR _1847_/S sky130_fd_sc_hd__clkbuf_2
XTAP_TAPCELL_ROW_10_179 VGND VPWR sky130_fd_sc_hd__tapvpwrvgnd_1
XPHY_EDGE_ROW_31_Left_93 VGND VGND VPWR VPWR sky130_fd_sc_hd__decap_3
XFILLER_31_221 VGND VGND VPWR VPWR sky130_fd_sc_hd__decap_3
XFILLER_31_254 VGND VGND VPWR VPWR sky130_fd_sc_hd__fill_2
X_1703_ _1986_/Q _1699_/X _1702_/Y VGND VGND VPWR VPWR _1986_/D sky130_fd_sc_hd__a21o_1
X_1634_ _1634_/A _1634_/B _1634_/C VGND VGND VPWR VPWR _1921_/D sky130_fd_sc_hd__nor3_1
XFILLER_58_118 VGND VGND VPWR VPWR sky130_fd_sc_hd__fill_1
X_1565_ _1635_/A _1340_/X VGND VGND VPWR VPWR _1567_/C sky130_fd_sc_hd__nor2b_1
X_1496_ _1600_/A _1929_/Q _1556_/B1 VGND VGND VPWR VPWR _1496_/Y sky130_fd_sc_hd__o21ai_0
XTAP_TAPCELL_ROW_1_136 VGND VPWR sky130_fd_sc_hd__tapvpwrvgnd_1
X_2117_ clkload9/A _2117_/D fanout69/A VGND VGND VPWR VPWR _2117_/Q sky130_fd_sc_hd__dfrtp_1
X_2048_ _2223_/CLK _2048_/D wire86/X VGND VGND VPWR VPWR _2048_/Q sky130_fd_sc_hd__dfrtp_1
XFILLER_13_57 VGND VGND VPWR VPWR sky130_fd_sc_hd__decap_4
XTAP_TAPCELL_ROW_24_249 VGND VPWR sky130_fd_sc_hd__tapvpwrvgnd_1
XTAP_TAPCELL_ROW_32_293 VGND VPWR sky130_fd_sc_hd__tapvpwrvgnd_1
Xfanout14 _1627_/B VGND VGND VPWR VPWR _1632_/B sky130_fd_sc_hd__clkdlybuf4s50_1
Xfanout69 fanout69/A VGND VGND VPWR VPWR fanout69/X sky130_fd_sc_hd__clkdlybuf4s50_1
XFILLER_13_265 VGND VGND VPWR VPWR sky130_fd_sc_hd__fill_1
XFILLER_9_225 VGND VGND VPWR VPWR sky130_fd_sc_hd__fill_2
XTAP_TAPCELL_ROW_15_205 VGND VPWR sky130_fd_sc_hd__tapvpwrvgnd_1
XFILLER_9_247 VGND VGND VPWR VPWR sky130_fd_sc_hd__decap_6
X_1350_ _2186_/Q _2170_/Q _1356_/S VGND VGND VPWR VPWR _1350_/Y sky130_fd_sc_hd__mux2i_1
X_1281_ _1216_/A _1279_/X _1280_/Y VGND VGND VPWR VPWR _1281_/Y sky130_fd_sc_hd__a21oi_1
XTAP_TAPCELL_ROW_38_319 VGND VPWR sky130_fd_sc_hd__tapvpwrvgnd_1
XTAP_TAPCELL_ROW_46_363 VGND VPWR sky130_fd_sc_hd__tapvpwrvgnd_1
X_0996_ _2139_/Q _2154_/Q _0996_/C _0996_/D VGND VGND VPWR VPWR _1668_/S sky130_fd_sc_hd__nor4_2
Xfanout204 _1374_/S VGND VGND VPWR VPWR _1368_/S sky130_fd_sc_hd__clkdlybuf4s50_1
X_1617_ _1617_/A _1617_/B _1617_/C VGND VGND VPWR VPWR _1617_/Y sky130_fd_sc_hd__nor3_1
Xfanout215 _1923_/Q VGND VGND VPWR VPWR _1652_/C sky130_fd_sc_hd__clkdlybuf4s50_1
X_1548_ _1625_/A _1942_/Q _1552_/B1 VGND VGND VPWR VPWR _1548_/Y sky130_fd_sc_hd__o21ai_0
X_1479_ _1774_/D _1478_/C _1478_/A VGND VGND VPWR VPWR _1479_/Y sky130_fd_sc_hd__a21oi_1
XFILLER_10_268 VGND VGND VPWR VPWR sky130_fd_sc_hd__decap_3
XFILLER_40_66 VGND VGND VPWR VPWR sky130_fd_sc_hd__fill_2
XFILLER_6_239 VGND VGND VPWR VPWR sky130_fd_sc_hd__fill_1
XTAP_TAPCELL_ROW_20_230 VGND VPWR sky130_fd_sc_hd__tapvpwrvgnd_1
Xhold291 _1896_/Q VGND VGND VPWR VPWR hold291/X sky130_fd_sc_hd__dlygate4sd3_1
Xhold280 _1919_/Q VGND VGND VPWR VPWR hold280/X sky130_fd_sc_hd__dlygate4sd3_1
XTAP_TAPCELL_ROW_43_344 VGND VPWR sky130_fd_sc_hd__tapvpwrvgnd_1
XFILLER_5_272 VGND VGND VPWR VPWR sky130_fd_sc_hd__decap_8
X_1402_ _1450_/A3 _1400_/X _1401_/Y VGND VGND VPWR VPWR _1940_/D sky130_fd_sc_hd__a21oi_1
Xinput4 duio_in[3] VGND VGND VPWR VPWR input4/X sky130_fd_sc_hd__buf_2
X_1333_ _1333_/A _1333_/B _1333_/C VGND VGND VPWR VPWR _1333_/X sky130_fd_sc_hd__xnor3_1
X_1264_ _2170_/Q _1264_/B _1269_/B VGND VGND VPWR VPWR _1264_/X sky130_fd_sc_hd__xor3_1
XTAP_TAPCELL_ROW_34_300 VGND VPWR sky130_fd_sc_hd__tapvpwrvgnd_1
X_1195_ _1331_/S _2215_/Q VGND VGND VPWR VPWR _1195_/Y sky130_fd_sc_hd__nor2b_1
X_0979_ _1629_/A _1629_/B _1440_/A1 VGND VGND VPWR VPWR _0979_/Y sky130_fd_sc_hd__o21ai_0
XFILLER_19_67 VGND VGND VPWR VPWR sky130_fd_sc_hd__decap_8
XTAP_TAPCELL_ROW_57_414 VGND VPWR sky130_fd_sc_hd__tapvpwrvgnd_1
XFILLER_2_253 VGND VGND VPWR VPWR sky130_fd_sc_hd__fill_1
XFILLER_33_113 VGND VGND VPWR VPWR sky130_fd_sc_hd__decap_6
XFILLER_33_146 VGND VGND VPWR VPWR sky130_fd_sc_hd__fill_1
X_1951_ clkload5/A _1951_/D _1959_/DE VGND VGND VPWR VPWR _1951_/Q sky130_fd_sc_hd__edfxtp_1
X_1882_ _2109_/Q hold283/X _1882_/S VGND VGND VPWR VPWR _2109_/D sky130_fd_sc_hd__mux2_1
X_1316_ _1315_/B _1315_/A _1248_/B VGND VGND VPWR VPWR _1316_/Y sky130_fd_sc_hd__o21ai_0
X_1247_ _1247_/A _1247_/B _1247_/C VGND VGND VPWR VPWR _1248_/A sky130_fd_sc_hd__nand3_1
X_1178_ _1240_/A _2209_/Q _1177_/Y _1297_/A2 VGND VGND VPWR VPWR _1178_/X sky130_fd_sc_hd__a211o_1
XFILLER_47_205 VGND VGND VPWR VPWR sky130_fd_sc_hd__fill_1
XFILLER_15_113 VGND VGND VPWR VPWR sky130_fd_sc_hd__fill_2
XFILLER_15_146 VGND VGND VPWR VPWR sky130_fd_sc_hd__decap_6
Xmax_cap99 _1690_/S VGND VGND VPWR VPWR _1682_/S sky130_fd_sc_hd__clkbuf_2
Xmax_cap44 _1025_/A VGND VGND VPWR VPWR _1035_/D sky130_fd_sc_hd__clkbuf_2
XFILLER_11_90 VGND VGND VPWR VPWR sky130_fd_sc_hd__fill_2
X_2150_ _2219_/CLK _2150_/D input1/X VGND VGND VPWR VPWR _2150_/Q sky130_fd_sc_hd__dfrtp_1
X_2081_ clkload0/A _2081_/D fanout56/X VGND VGND VPWR VPWR _2081_/Q sky130_fd_sc_hd__dfrtp_1
X_1101_ _1100_/X _2221_/Q _1368_/S VGND VGND VPWR VPWR _1101_/Y sky130_fd_sc_hd__mux2i_1
X_1032_ _1035_/D _1025_/B _1048_/C _1024_/Y VGND VGND VPWR VPWR _1032_/Y sky130_fd_sc_hd__a31oi_1
X_1934_ clkload6/A _1934_/D _1950_/DE VGND VGND VPWR VPWR _1934_/Q sky130_fd_sc_hd__edfxtp_1
X_1865_ _0969_/D _2092_/Q _1866_/S VGND VGND VPWR VPWR _2092_/D sky130_fd_sc_hd__mux2_1
X_1796_ _0972_/A _2033_/Q wire12/X VGND VGND VPWR VPWR _2033_/D sky130_fd_sc_hd__mux2_1
XFILLER_12_105 VGND VGND VPWR VPWR sky130_fd_sc_hd__fill_2
XFILLER_32_23 VGND VGND VPWR VPWR sky130_fd_sc_hd__fill_1
XTAP_TAPCELL_ROW_7_164 VGND VPWR sky130_fd_sc_hd__tapvpwrvgnd_1
XPHY_EDGE_ROW_44_Left_106 VGND VGND VPWR VPWR sky130_fd_sc_hd__decap_3
X_1650_ _0965_/C _0980_/Y _1644_/Y _1649_/Y fanout8/X VGND VGND VPWR VPWR _1650_/Y
+ sky130_fd_sc_hd__o311ai_0
X_1581_ _1933_/Q _1620_/A VGND VGND VPWR VPWR _1582_/A sky130_fd_sc_hd__nor2b_1
XFILLER_21_3 VGND VGND VPWR VPWR sky130_fd_sc_hd__decap_3
X_2202_ _2219_/CLK _2202_/D VGND VGND VPWR VPWR _2202_/Q sky130_fd_sc_hd__dfxtp_1
XPHY_EDGE_ROW_53_Left_115 VGND VGND VPWR VPWR sky130_fd_sc_hd__decap_3
X_1015_ _1015_/A _1015_/B VGND VGND VPWR VPWR _1054_/A sky130_fd_sc_hd__nand2_1
X_2133_ _2208_/CLK _2133_/D fanout80/X VGND VGND VPWR VPWR _2133_/Q sky130_fd_sc_hd__dfrtp_1
X_2064_ clkload1/A _2064_/D load_slew60/X VGND VGND VPWR VPWR _2064_/Q sky130_fd_sc_hd__dfrtp_1
X_1917_ clkload1/A _1917_/D VGND VGND VPWR VPWR _1917_/Q sky130_fd_sc_hd__dfxtp_1
X_1848_ _2077_/Q _0969_/C _1848_/S VGND VGND VPWR VPWR _2077_/D sky130_fd_sc_hd__mux2_1
X_1779_ _0969_/B _2018_/Q _1781_/S VGND VGND VPWR VPWR _2018_/D sky130_fd_sc_hd__mux2_1
XFILLER_40_266 VGND VGND VPWR VPWR sky130_fd_sc_hd__fill_1
XFILLER_16_241 VGND VGND VPWR VPWR sky130_fd_sc_hd__fill_1
XFILLER_31_277 VGND VGND VPWR VPWR sky130_fd_sc_hd__decap_3
X_1702_ _1985_/Q _1986_/Q _1701_/Y VGND VGND VPWR VPWR _1702_/Y sky130_fd_sc_hd__a21oi_1
X_1633_ _1921_/Q _1617_/B _1632_/Y VGND VGND VPWR VPWR _1634_/C sky130_fd_sc_hd__a21oi_1
X_1564_ _1609_/A _1609_/B _1564_/C VGND VGND VPWR VPWR _1907_/D sky130_fd_sc_hd__nor3_1
X_1495_ _1890_/Q _1552_/B1 _1494_/Y _1495_/B1 VGND VGND VPWR VPWR _1890_/D sky130_fd_sc_hd__o31a_1
XFILLER_22_222 VGND VGND VPWR VPWR sky130_fd_sc_hd__fill_1
XTAP_TAPCELL_ROW_1_137 VGND VPWR sky130_fd_sc_hd__tapvpwrvgnd_1
Xfanout15 _1562_/B VGND VGND VPWR VPWR _1627_/B sky130_fd_sc_hd__clkdlybuf4s50_1
Xfanout26 _0967_/X VGND VGND VPWR VPWR _1954_/DE sky130_fd_sc_hd__clkdlybuf4s50_1
X_2116_ clkload0/A _2116_/D fanout56/X VGND VGND VPWR VPWR _2116_/Q sky130_fd_sc_hd__dfrtp_1
X_2047_ _2219_/CLK _2047_/D fanout91/X VGND VGND VPWR VPWR _2047_/Q sky130_fd_sc_hd__dfrtp_1
Xfanout59 fanout59/A VGND VGND VPWR VPWR fanout59/X sky130_fd_sc_hd__clkdlybuf4s50_1
XTAP_TAPCELL_ROW_15_206 VGND VPWR sky130_fd_sc_hd__tapvpwrvgnd_1
XFILLER_48_141 VGND VGND VPWR VPWR sky130_fd_sc_hd__fill_2
X_1280_ _1216_/A _2205_/Q _1285_/B1 VGND VGND VPWR VPWR _1280_/Y sky130_fd_sc_hd__o21ai_0
X_0995_ _2139_/Q _2154_/Q _0996_/D VGND VGND VPWR VPWR _0995_/Y sky130_fd_sc_hd__nor3_2
Xfanout205 _1207_/A VGND VGND VPWR VPWR _1374_/S sky130_fd_sc_hd__clkdlybuf4s50_1
X_1616_ _1940_/Q _1615_/A VGND VGND VPWR VPWR _1617_/A sky130_fd_sc_hd__nor2b_1
X_1547_ _1634_/A _1634_/B _1547_/C VGND VGND VPWR VPWR _1903_/D sky130_fd_sc_hd__nor3_1
X_1478_ _1478_/A _1478_/B _1478_/C VGND VGND VPWR VPWR _2127_/D sky130_fd_sc_hd__nor3_1
XTAP_TAPCELL_ROW_52_389 VGND VPWR sky130_fd_sc_hd__tapvpwrvgnd_1
XFILLER_6_229 VGND VGND VPWR VPWR sky130_fd_sc_hd__decap_3
XTAP_TAPCELL_ROW_20_231 VGND VPWR sky130_fd_sc_hd__tapvpwrvgnd_1
Xhold292 _2057_/Q VGND VGND VPWR VPWR hold292/X sky130_fd_sc_hd__dlygate4sd3_1
Xhold281 _1892_/Q VGND VGND VPWR VPWR hold281/X sky130_fd_sc_hd__dlygate4sd3_1
Xhold270 _2042_/Q VGND VGND VPWR VPWR hold270/X sky130_fd_sc_hd__dlygate4sd3_1
XFILLER_60_136 VGND VGND VPWR VPWR sky130_fd_sc_hd__fill_1
XTAP_TAPCELL_ROW_43_345 VGND VPWR sky130_fd_sc_hd__tapvpwrvgnd_1
X_1401_ _2089_/Q _1451_/B2 _1456_/B1 _2073_/Q VGND VGND VPWR VPWR _1401_/Y sky130_fd_sc_hd__o22ai_1
X_1332_ _1943_/Q _1945_/Q VGND VGND VPWR VPWR _1333_/C sky130_fd_sc_hd__xor2_1
X_1263_ _2187_/Q _2222_/Q VGND VGND VPWR VPWR _1269_/B sky130_fd_sc_hd__xor2_1
X_1194_ _2037_/Q _1307_/A2 _1192_/Y _1193_/Y VGND VGND VPWR VPWR _2230_/D sky130_fd_sc_hd__o2bb2ai_1
XFILLER_51_147 VGND VGND VPWR VPWR sky130_fd_sc_hd__fill_2
XTAP_TAPCELL_ROW_34_301 VGND VPWR sky130_fd_sc_hd__tapvpwrvgnd_1
X_0978_ _0978_/A VGND VGND VPWR VPWR _2144_/D sky130_fd_sc_hd__inv_1
XFILLER_19_57 VGND VGND VPWR VPWR sky130_fd_sc_hd__fill_2
XFILLER_27_166 VGND VGND VPWR VPWR sky130_fd_sc_hd__fill_2
XFILLER_35_23 VGND VGND VPWR VPWR sky130_fd_sc_hd__fill_2
XTAP_TAPCELL_ROW_57_415 VGND VPWR sky130_fd_sc_hd__tapvpwrvgnd_1
XFILLER_51_55 VGND VGND VPWR VPWR sky130_fd_sc_hd__fill_1
Xclkbuf_leaf_6_dclk clkbuf_leaf_9_dclk/A VGND VGND VPWR VPWR _2166_/CLK sky130_fd_sc_hd__clkbuf_16
X_1950_ clkload6/A _1950_/D _1950_/DE VGND VGND VPWR VPWR _1950_/Q sky130_fd_sc_hd__edfxtp_1
X_1881_ _2108_/Q _1905_/Q _1885_/S VGND VGND VPWR VPWR _2108_/D sky130_fd_sc_hd__mux2_1
X_1315_ _1315_/A _1315_/B VGND VGND VPWR VPWR _1315_/X sky130_fd_sc_hd__and2_0
XFILLER_2_82 VGND VGND VPWR VPWR sky130_fd_sc_hd__fill_2
X_1246_ _1247_/A _1247_/B _1247_/C VGND VGND VPWR VPWR _1246_/Y sky130_fd_sc_hd__a21oi_1
X_1177_ _1240_/A _2177_/Q VGND VGND VPWR VPWR _1177_/Y sky130_fd_sc_hd__nor2b_1
XFILLER_15_169 VGND VGND VPWR VPWR sky130_fd_sc_hd__decap_3
Xmax_cap45 _1035_/C VGND VGND VPWR VPWR _1042_/B1 sky130_fd_sc_hd__clkdlybuf4s25_1
X_2080_ clkload1/A _2080_/D fanout59/X VGND VGND VPWR VPWR _2080_/Q sky130_fd_sc_hd__dfrtp_1
X_1100_ _2189_/Q _1100_/B _1104_/B VGND VGND VPWR VPWR _1100_/X sky130_fd_sc_hd__xnor3_1
X_1031_ _1031_/A _1031_/B _1031_/C VGND VGND VPWR VPWR _1040_/A sky130_fd_sc_hd__nand3_1
X_1933_ clkload6/A _1933_/D _1950_/DE VGND VGND VPWR VPWR _1933_/Q sky130_fd_sc_hd__edfxtp_1
X_1864_ _0969_/A _2091_/Q _1866_/S VGND VGND VPWR VPWR _2091_/D sky130_fd_sc_hd__mux2_1
X_1795_ _1824_/A0 _2032_/Q wire12/A VGND VGND VPWR VPWR _2032_/D sky130_fd_sc_hd__mux2_1
XFILLER_37_272 VGND VGND VPWR VPWR sky130_fd_sc_hd__decap_3
XFILLER_52_242 VGND VGND VPWR VPWR sky130_fd_sc_hd__fill_1
X_1229_ _1392_/S _2194_/Q _1228_/Y _1307_/A2 VGND VGND VPWR VPWR _1229_/X sky130_fd_sc_hd__a211o_1
XTAP_TAPCELL_ROW_7_165 VGND VPWR sky130_fd_sc_hd__tapvpwrvgnd_1
X_1580_ _1620_/A _1358_/X VGND VGND VPWR VPWR _1582_/C sky130_fd_sc_hd__nor2b_1
X_2201_ _2223_/CLK _2201_/D VGND VGND VPWR VPWR _2201_/Q sky130_fd_sc_hd__dfxtp_1
X_2132_ _2208_/CLK _2132_/D fanout80/X VGND VGND VPWR VPWR _2132_/Q sky130_fd_sc_hd__dfrtp_1
X_1014_ _1014_/A _1014_/B VGND VGND VPWR VPWR _1015_/B sky130_fd_sc_hd__nand2_1
X_2063_ clkload8/A _2063_/D load_slew70/X VGND VGND VPWR VPWR _2063_/Q sky130_fd_sc_hd__dfrtp_1
X_1916_ clkload8/A _1916_/D VGND VGND VPWR VPWR _1916_/Q sky130_fd_sc_hd__dfxtp_1
X_1847_ _2076_/Q _0969_/D _1847_/S VGND VGND VPWR VPWR _2076_/D sky130_fd_sc_hd__mux2_1
X_1778_ _0972_/A _2017_/Q _1781_/S VGND VGND VPWR VPWR _2017_/D sky130_fd_sc_hd__mux2_1
XFILLER_16_264 VGND VGND VPWR VPWR sky130_fd_sc_hd__fill_1
X_1701_ _1985_/Q _1986_/Q _0995_/Y VGND VGND VPWR VPWR _1701_/Y sky130_fd_sc_hd__o21ai_0
X_1632_ _1632_/A _1632_/B _1632_/C VGND VGND VPWR VPWR _1632_/Y sky130_fd_sc_hd__nor3_1
X_1563_ _1907_/Q _1562_/B _1562_/Y VGND VGND VPWR VPWR _1564_/C sky130_fd_sc_hd__a21oi_1
X_1494_ _2141_/Q _2140_/Q VGND VGND VPWR VPWR _1494_/Y sky130_fd_sc_hd__nor2b_1
XTAP_TAPCELL_ROW_1_138 VGND VPWR sky130_fd_sc_hd__tapvpwrvgnd_1
X_2115_ clkload6/A _2115_/D load_slew58/X VGND VGND VPWR VPWR _2115_/Q sky130_fd_sc_hd__dfrtp_1
Xfanout16 _1637_/B VGND VGND VPWR VPWR _1607_/B sky130_fd_sc_hd__clkdlybuf4s50_1
X_2046_ clkload3/A _2046_/D fanout66/X VGND VGND VPWR VPWR _2046_/Q sky130_fd_sc_hd__dfrtp_1
XFILLER_57_175 VGND VGND VPWR VPWR sky130_fd_sc_hd__fill_1
XTAP_TAPCELL_ROW_15_207 VGND VPWR sky130_fd_sc_hd__tapvpwrvgnd_1
XFILLER_8_271 VGND VGND VPWR VPWR sky130_fd_sc_hd__fill_2
X_0994_ _1985_/Q _1986_/Q _1987_/Q VGND VGND VPWR VPWR _0996_/C sky130_fd_sc_hd__nand3_1
Xfanout206 _1356_/S VGND VGND VPWR VPWR _1210_/A sky130_fd_sc_hd__clkdlybuf4s50_1
X_1615_ _1615_/A _1400_/X VGND VGND VPWR VPWR _1617_/C sky130_fd_sc_hd__nor2b_1
X_1546_ _1903_/Q _1617_/B _1545_/Y VGND VGND VPWR VPWR _1547_/C sky130_fd_sc_hd__a21oi_1
X_1477_ _1773_/C _1840_/A _2127_/Q VGND VGND VPWR VPWR _1801_/A sky130_fd_sc_hd__nand3_1
XFILLER_24_25 VGND VGND VPWR VPWR sky130_fd_sc_hd__decap_3
XTAP_TAPCELL_ROW_20_232 VGND VPWR sky130_fd_sc_hd__tapvpwrvgnd_1
X_2029_ _2224_/CLK _2029_/D fanout87/X VGND VGND VPWR VPWR _2029_/Q sky130_fd_sc_hd__dfrtp_1
Xhold260 _2053_/Q VGND VGND VPWR VPWR hold260/X sky130_fd_sc_hd__dlygate4sd3_1
Xhold271 _2043_/Q VGND VGND VPWR VPWR hold271/X sky130_fd_sc_hd__dlygate4sd3_1
XFILLER_49_99 VGND VGND VPWR VPWR sky130_fd_sc_hd__fill_1
Xhold293 _2051_/Q VGND VGND VPWR VPWR hold293/X sky130_fd_sc_hd__dlygate4sd3_1
Xhold282 _1902_/Q VGND VGND VPWR VPWR hold282/X sky130_fd_sc_hd__dlygate4sd3_1
XTAP_TAPCELL_ROW_43_346 VGND VPWR sky130_fd_sc_hd__tapvpwrvgnd_1
XFILLER_5_241 VGND VGND VPWR VPWR sky130_fd_sc_hd__fill_2
X_1400_ _1400_/A _1400_/B _1400_/C VGND VGND VPWR VPWR _1400_/X sky130_fd_sc_hd__xnor3_1
X_1331_ _2183_/Q _2167_/Q _1331_/S VGND VGND VPWR VPWR _1333_/B sky130_fd_sc_hd__mux2i_1
X_1262_ hold265/X _1329_/A2 _1261_/X VGND VGND VPWR VPWR _2185_/D sky130_fd_sc_hd__a21o_1
X_1193_ _1422_/S _2182_/Q _1310_/B1 VGND VGND VPWR VPWR _1193_/Y sky130_fd_sc_hd__o21ai_0
XTAP_TAPCELL_ROW_34_302 VGND VPWR sky130_fd_sc_hd__tapvpwrvgnd_1
X_0977_ _0977_/A _1721_/D _1858_/A VGND VGND VPWR VPWR _0978_/A sky130_fd_sc_hd__nand3_1
XTAP_TAPCELL_ROW_57_416 VGND VPWR sky130_fd_sc_hd__tapvpwrvgnd_1
X_1529_ _1600_/A _1382_/X _1528_/Y VGND VGND VPWR VPWR _1529_/Y sky130_fd_sc_hd__a21oi_1
XFILLER_27_189 VGND VGND VPWR VPWR sky130_fd_sc_hd__fill_1
XFILLER_35_57 VGND VGND VPWR VPWR sky130_fd_sc_hd__decap_8
XPHY_EDGE_ROW_14_Right_14 VGND VGND VPWR VPWR sky130_fd_sc_hd__decap_3
XPHY_EDGE_ROW_23_Right_23 VGND VGND VPWR VPWR sky130_fd_sc_hd__decap_3
XFILLER_18_167 VGND VGND VPWR VPWR sky130_fd_sc_hd__fill_2
XPHY_EDGE_ROW_32_Right_32 VGND VGND VPWR VPWR sky130_fd_sc_hd__decap_3
X_1880_ _2107_/Q _1904_/Q _1880_/S VGND VGND VPWR VPWR _2107_/D sky130_fd_sc_hd__mux2_1
XPHY_EDGE_ROW_41_Right_41 VGND VGND VPWR VPWR sky130_fd_sc_hd__decap_3
X_1314_ _2180_/Q _1321_/B VGND VGND VPWR VPWR _1315_/A sky130_fd_sc_hd__xor2_1
XPHY_EDGE_ROW_50_Right_50 VGND VGND VPWR VPWR sky130_fd_sc_hd__decap_3
X_1245_ _2183_/Q _1253_/B _1245_/C VGND VGND VPWR VPWR _1247_/C sky130_fd_sc_hd__xnor3_1
X_1176_ _2031_/Q _1444_/A3 _1175_/X VGND VGND VPWR VPWR _2224_/D sky130_fd_sc_hd__o21a_1
XPHY_EDGE_ROW_6_Left_68 VGND VGND VPWR VPWR sky130_fd_sc_hd__decap_3
X_1030_ _1045_/C _1049_/B _1055_/A VGND VGND VPWR VPWR _1031_/B sky130_fd_sc_hd__nand3_1
X_1932_ clkload7/A _1932_/D _1950_/DE VGND VGND VPWR VPWR _1932_/Q sky130_fd_sc_hd__edfxtp_1
X_1863_ _0969_/B _2090_/Q _1866_/S VGND VGND VPWR VPWR _2090_/D sky130_fd_sc_hd__mux2_1
X_1794_ _1718_/D _2031_/Q wire12/A VGND VGND VPWR VPWR _2031_/D sky130_fd_sc_hd__mux2_1
X_1228_ _1392_/S _2226_/Q VGND VGND VPWR VPWR _1228_/Y sky130_fd_sc_hd__nor2b_1
X_1159_ _2203_/Q _1356_/S VGND VGND VPWR VPWR _1159_/Y sky130_fd_sc_hd__nor2b_1
XFILLER_20_195 VGND VGND VPWR VPWR sky130_fd_sc_hd__fill_1
XTAP_TAPCELL_ROW_7_166 VGND VPWR sky130_fd_sc_hd__tapvpwrvgnd_1
XFILLER_7_111 VGND VGND VPWR VPWR sky130_fd_sc_hd__fill_1
XFILLER_7_133 VGND VGND VPWR VPWR sky130_fd_sc_hd__decap_3
XFILLER_7_166 VGND VGND VPWR VPWR sky130_fd_sc_hd__fill_2
X_2200_ _2223_/CLK _2200_/D VGND VGND VPWR VPWR _2200_/Q sky130_fd_sc_hd__dfxtp_1
X_2131_ _2208_/CLK _2131_/D fanout80/X VGND VGND VPWR VPWR _2131_/Q sky130_fd_sc_hd__dfrtp_1
X_2062_ clkload2/A _2062_/D fanout59/A VGND VGND VPWR VPWR _2062_/Q sky130_fd_sc_hd__dfrtp_1
X_1013_ _1025_/A _1013_/B _1013_/C _1652_/B VGND VGND VPWR VPWR _1015_/A sky130_fd_sc_hd__nand4_1
XTAP_TAPCELL_ROW_12_190 VGND VPWR sky130_fd_sc_hd__tapvpwrvgnd_1
X_1915_ clkload8/A _1915_/D VGND VGND VPWR VPWR _1915_/Q sky130_fd_sc_hd__dfxtp_1
X_1846_ _2075_/Q _0969_/A _1847_/S VGND VGND VPWR VPWR _2075_/D sky130_fd_sc_hd__mux2_1
X_1777_ _1824_/A0 _2016_/Q _1781_/S VGND VGND VPWR VPWR _2016_/D sky130_fd_sc_hd__mux2_1
XPHY_EDGE_ROW_4_Right_4 VGND VGND VPWR VPWR sky130_fd_sc_hd__decap_3
XFILLER_43_24 VGND VGND VPWR VPWR sky130_fd_sc_hd__fill_1
XFILLER_4_29 VGND VGND VPWR VPWR sky130_fd_sc_hd__decap_3
XPHY_EDGE_ROW_9_Left_71 VGND VGND VPWR VPWR sky130_fd_sc_hd__decap_3
XTAP_TAPCELL_ROW_26_260 VGND VPWR sky130_fd_sc_hd__tapvpwrvgnd_1
XFILLER_33_90 VGND VGND VPWR VPWR sky130_fd_sc_hd__fill_1
X_1700_ _0995_/Y _1699_/X _1985_/Q VGND VGND VPWR VPWR _1985_/D sky130_fd_sc_hd__mux2_1
X_1631_ _1943_/Q _1630_/A VGND VGND VPWR VPWR _1632_/A sky130_fd_sc_hd__nor2b_1
X_1562_ _1562_/A _1562_/B _1562_/C VGND VGND VPWR VPWR _1562_/Y sky130_fd_sc_hd__nor3_1
X_1493_ _2162_/Q _2160_/Q _2161_/Q _1492_/X VGND VGND VPWR VPWR _2139_/D sky130_fd_sc_hd__o31a_1
XTAP_TAPCELL_ROW_49_374 VGND VPWR sky130_fd_sc_hd__tapvpwrvgnd_1
X_2114_ clkload7/A _2114_/D load_slew58/X VGND VGND VPWR VPWR _2114_/Q sky130_fd_sc_hd__dfrtp_1
X_2045_ _2224_/CLK _2045_/D fanout88/X VGND VGND VPWR VPWR _2045_/Q sky130_fd_sc_hd__dfstp_2
Xfanout17 _1562_/B VGND VGND VPWR VPWR _1637_/B sky130_fd_sc_hd__clkdlybuf4s50_1
X_1829_ _0969_/C _2061_/Q _1829_/S VGND VGND VPWR VPWR _2061_/D sky130_fd_sc_hd__mux2_1
XTAP_TAPCELL_ROW_15_208 VGND VPWR sky130_fd_sc_hd__tapvpwrvgnd_1
XFILLER_13_279 VGND VGND VPWR VPWR sky130_fd_sc_hd__fill_1
XPHY_EDGE_ROW_35_Left_97 VGND VGND VPWR VPWR sky130_fd_sc_hd__decap_3
X_0993_ _0977_/A _1721_/D _1858_/A _0992_/Y VGND VGND VPWR VPWR _2143_/D sky130_fd_sc_hd__a31oi_1
X_1614_ _1614_/A _1614_/B _1614_/C VGND VGND VPWR VPWR _1917_/D sky130_fd_sc_hd__nor3_1
XFILLER_5_83 VGND VGND VPWR VPWR sky130_fd_sc_hd__fill_2
Xfanout207 _1207_/A VGND VGND VPWR VPWR _1356_/S sky130_fd_sc_hd__clkdlybuf4s50_1
X_1545_ _1620_/A _1406_/X _1544_/Y VGND VGND VPWR VPWR _1545_/Y sky130_fd_sc_hd__a21oi_1
X_1476_ _1773_/C _2126_/Q _1840_/B VGND VGND VPWR VPWR _1478_/C sky130_fd_sc_hd__and3_1
XPHY_EDGE_ROW_59_Left_121 VGND VGND VPWR VPWR sky130_fd_sc_hd__decap_3
X_2028_ _2221_/CLK _2028_/D fanout87/X VGND VGND VPWR VPWR _2028_/Q sky130_fd_sc_hd__dfrtp_1
XFILLER_10_205 VGND VGND VPWR VPWR sky130_fd_sc_hd__fill_2
XFILLER_10_216 VGND VGND VPWR VPWR sky130_fd_sc_hd__decap_3
XTAP_TAPCELL_ROW_20_233 VGND VPWR sky130_fd_sc_hd__tapvpwrvgnd_1
Xhold250 _2156_/Q VGND VGND VPWR VPWR _2157_/D sky130_fd_sc_hd__dlygate4sd3_1
Xhold261 _2061_/Q VGND VGND VPWR VPWR hold261/X sky130_fd_sc_hd__dlygate4sd3_1
Xhold283 _1906_/Q VGND VGND VPWR VPWR hold283/X sky130_fd_sc_hd__dlygate4sd3_1
Xhold272 _1909_/Q VGND VGND VPWR VPWR hold272/X sky130_fd_sc_hd__dlygate4sd3_1
XFILLER_45_113 VGND VGND VPWR VPWR sky130_fd_sc_hd__fill_2
XTAP_TAPCELL_ROW_43_347 VGND VPWR sky130_fd_sc_hd__tapvpwrvgnd_1
X_1330_ _1937_/Q _1944_/Q VGND VGND VPWR VPWR _1333_/A sky130_fd_sc_hd__nand2_1
X_1261_ _1362_/S _2201_/Q _1260_/Y _1259_/X _1327_/B1 VGND VGND VPWR VPWR _1261_/X
+ sky130_fd_sc_hd__o221a_1
XFILLER_36_168 VGND VGND VPWR VPWR sky130_fd_sc_hd__fill_1
XTAP_TAPCELL_ROW_34_303 VGND VPWR sky130_fd_sc_hd__tapvpwrvgnd_1
X_1192_ _2214_/Q _1240_/A VGND VGND VPWR VPWR _1192_/Y sky130_fd_sc_hd__nor2b_1
X_0976_ _1858_/A _0976_/B VGND VGND VPWR VPWR _0976_/Y sky130_fd_sc_hd__nand2_1
XFILLER_19_37 VGND VGND VPWR VPWR sky130_fd_sc_hd__fill_2
XTAP_TAPCELL_ROW_57_417 VGND VPWR sky130_fd_sc_hd__tapvpwrvgnd_1
X_1528_ _1600_/A _1937_/Q _1556_/B1 VGND VGND VPWR VPWR _1528_/Y sky130_fd_sc_hd__o21ai_0
X_1459_ _2143_/Q _1459_/B _1664_/B _1890_/Q VGND VGND VPWR VPWR _1459_/Y sky130_fd_sc_hd__nor4b_2
XFILLER_35_14 VGND VGND VPWR VPWR sky130_fd_sc_hd__fill_1
XFILLER_35_69 VGND VGND VPWR VPWR sky130_fd_sc_hd__decap_6
XFILLER_41_160 VGND VGND VPWR VPWR sky130_fd_sc_hd__decap_3
XFILLER_37_3 VGND VGND VPWR VPWR sky130_fd_sc_hd__fill_2
XPHY_EDGE_ROW_22_Left_84 VGND VGND VPWR VPWR sky130_fd_sc_hd__decap_3
X_1313_ _2216_/Q _2197_/Q VGND VGND VPWR VPWR _1321_/B sky130_fd_sc_hd__xor2_1
X_1244_ _2218_/Q _2167_/Q VGND VGND VPWR VPWR _1245_/C sky130_fd_sc_hd__xnor2_1
X_1175_ _1386_/S _2208_/Q _1174_/Y _1297_/A2 VGND VGND VPWR VPWR _1175_/X sky130_fd_sc_hd__a211o_1
X_0959_ _1927_/Q _1656_/B _1656_/C VGND VGND VPWR VPWR _0959_/Y sky130_fd_sc_hd__nor3_1
XFILLER_46_68 VGND VGND VPWR VPWR sky130_fd_sc_hd__fill_2
Xmax_cap47 _1010_/Y VGND VGND VPWR VPWR _1025_/B sky130_fd_sc_hd__clkbuf_2
Xclkbuf_leaf_11_dclk clkbuf_leaf_9_dclk/A VGND VGND VPWR VPWR _2223_/CLK sky130_fd_sc_hd__clkbuf_16
X_1931_ clkload2/A _1931_/D _1955_/DE VGND VGND VPWR VPWR _1931_/Q sky130_fd_sc_hd__edfxtp_1
X_1862_ _0972_/A _2089_/Q _1866_/S VGND VGND VPWR VPWR _2089_/D sky130_fd_sc_hd__mux2_1
X_1793_ _1719_/B _2030_/Q wire12/A VGND VGND VPWR VPWR _2030_/D sky130_fd_sc_hd__mux2_1
XFILLER_37_252 VGND VGND VPWR VPWR sky130_fd_sc_hd__fill_2
X_1227_ _2016_/Q _1442_/A3 _1226_/X VGND VGND VPWR VPWR _2209_/D sky130_fd_sc_hd__o21a_1
X_1158_ _2025_/Q _1267_/A2 _1156_/Y _1157_/Y VGND VGND VPWR VPWR _2218_/D sky130_fd_sc_hd__o2bb2ai_1
XFILLER_32_37 VGND VGND VPWR VPWR sky130_fd_sc_hd__fill_2
X_1089_ _2187_/Q _1089_/B _1095_/B VGND VGND VPWR VPWR _1089_/X sky130_fd_sc_hd__xnor3_1
XFILLER_32_48 VGND VGND VPWR VPWR sky130_fd_sc_hd__fill_1
XTAP_TAPCELL_ROW_7_167 VGND VPWR sky130_fd_sc_hd__tapvpwrvgnd_1
XFILLER_22_81 VGND VGND VPWR VPWR sky130_fd_sc_hd__decap_3
X_1012_ _1013_/C _1652_/B _1013_/B VGND VGND VPWR VPWR _1014_/A sky130_fd_sc_hd__nand3_1
X_2130_ _2208_/CLK _2130_/D fanout80/X VGND VGND VPWR VPWR _2130_/Q sky130_fd_sc_hd__dfrtp_1
X_2061_ _2230_/CLK _2061_/D _2023_/SET_B VGND VGND VPWR VPWR _2061_/Q sky130_fd_sc_hd__dfrtp_1
X_1914_ clkload8/A _1914_/D VGND VGND VPWR VPWR _1914_/Q sky130_fd_sc_hd__dfxtp_1
XFILLER_8_50 VGND VGND VPWR VPWR sky130_fd_sc_hd__fill_2
XFILLER_8_83 VGND VGND VPWR VPWR sky130_fd_sc_hd__fill_1
XTAP_TAPCELL_ROW_12_191 VGND VPWR sky130_fd_sc_hd__tapvpwrvgnd_1
X_1845_ _2074_/Q _0969_/B _1847_/S VGND VGND VPWR VPWR _2074_/D sky130_fd_sc_hd__mux2_1
X_1776_ _0968_/A _2015_/Q _1782_/S VGND VGND VPWR VPWR _2015_/D sky130_fd_sc_hd__mux2_1
XFILLER_27_37 VGND VGND VPWR VPWR sky130_fd_sc_hd__fill_1
XPHY_EDGE_ROW_40_Left_102 VGND VGND VPWR VPWR sky130_fd_sc_hd__decap_3
XFILLER_31_225 VGND VGND VPWR VPWR sky130_fd_sc_hd__fill_2
XTAP_TAPCELL_ROW_26_261 VGND VPWR sky130_fd_sc_hd__tapvpwrvgnd_1
X_1630_ _1630_/A _1418_/X VGND VGND VPWR VPWR _1632_/C sky130_fd_sc_hd__nor2b_1
X_1561_ _1929_/Q _1600_/A VGND VGND VPWR VPWR _1562_/A sky130_fd_sc_hd__nor2b_1
X_1492_ _2162_/Q _2160_/Q _2161_/Q _2139_/Q VGND VGND VPWR VPWR _1492_/X sky130_fd_sc_hd__a31o_1
XTAP_TAPCELL_ROW_49_375 VGND VPWR sky130_fd_sc_hd__tapvpwrvgnd_1
X_2113_ clkload7/A _2113_/D _2145_/SET_B VGND VGND VPWR VPWR _2113_/Q sky130_fd_sc_hd__dfrtp_1
X_2044_ _2224_/CLK _2044_/D _2050_/SET_B VGND VGND VPWR VPWR _2044_/Q sky130_fd_sc_hd__dfstp_2
Xfanout18 _0989_/Y VGND VGND VPWR VPWR _1562_/B sky130_fd_sc_hd__clkdlybuf4s50_1
X_1828_ _0969_/D _2060_/Q _1828_/S VGND VGND VPWR VPWR _2060_/D sky130_fd_sc_hd__mux2_1
X_1759_ _0972_/A _2001_/Q wire39/A VGND VGND VPWR VPWR _2001_/D sky130_fd_sc_hd__mux2_1
XFILLER_57_133 VGND VGND VPWR VPWR sky130_fd_sc_hd__fill_2
XFILLER_13_225 VGND VGND VPWR VPWR sky130_fd_sc_hd__decap_4
Xclkbuf_leaf_9_dclk clkbuf_leaf_9_dclk/A VGND VGND VPWR VPWR _2221_/CLK sky130_fd_sc_hd__clkbuf_16
X_0992_ _1890_/Q _1444_/A3 _2143_/Q VGND VGND VPWR VPWR _0992_/Y sky130_fd_sc_hd__a21oi_1
XFILLER_8_251 VGND VGND VPWR VPWR sky130_fd_sc_hd__fill_1
X_1613_ _1917_/Q _1632_/B _1612_/Y VGND VGND VPWR VPWR _1614_/C sky130_fd_sc_hd__a21oi_1
X_1544_ _1620_/A _1941_/Q _1552_/B1 VGND VGND VPWR VPWR _1544_/Y sky130_fd_sc_hd__o21ai_0
XFILLER_39_111 VGND VGND VPWR VPWR sky130_fd_sc_hd__fill_1
Xfanout208 _1186_/A VGND VGND VPWR VPWR _1207_/A sky130_fd_sc_hd__clkdlybuf4s50_1
X_1475_ _1773_/C _2126_/Q _1840_/B VGND VGND VPWR VPWR _1478_/B sky130_fd_sc_hd__a21oi_1
XFILLER_24_38 VGND VGND VPWR VPWR sky130_fd_sc_hd__decap_3
X_2027_ _2221_/CLK _2027_/D fanout89/X VGND VGND VPWR VPWR _2027_/Q sky130_fd_sc_hd__dfstp_2
XFILLER_10_239 VGND VGND VPWR VPWR sky130_fd_sc_hd__decap_8
XFILLER_40_37 VGND VGND VPWR VPWR sky130_fd_sc_hd__fill_1
XFILLER_49_24 VGND VGND VPWR VPWR sky130_fd_sc_hd__fill_1
XFILLER_49_57 VGND VGND VPWR VPWR sky130_fd_sc_hd__fill_2
Xhold240 _2151_/Q VGND VGND VPWR VPWR _2152_/D sky130_fd_sc_hd__dlygate4sd3_1
Xhold251 _2157_/Q VGND VGND VPWR VPWR _2158_/D sky130_fd_sc_hd__dlygate4sd3_1
Xhold262 _1998_/Q VGND VGND VPWR VPWR hold262/X sky130_fd_sc_hd__dlygate4sd3_1
Xhold284 _1897_/Q VGND VGND VPWR VPWR hold284/X sky130_fd_sc_hd__dlygate4sd3_1
Xhold273 _1894_/Q VGND VGND VPWR VPWR hold273/X sky130_fd_sc_hd__dlygate4sd3_1
XFILLER_53_191 VGND VGND VPWR VPWR sky130_fd_sc_hd__decap_3
XTAP_TAPCELL_ROW_43_348 VGND VPWR sky130_fd_sc_hd__tapvpwrvgnd_1
XFILLER_5_254 VGND VGND VPWR VPWR sky130_fd_sc_hd__fill_2
X_1260_ _1259_/B _1259_/A _1362_/S VGND VGND VPWR VPWR _1260_/Y sky130_fd_sc_hd__o21ai_0
X_1191_ _2036_/Q _1310_/B1 _1190_/X VGND VGND VPWR VPWR _2229_/D sky130_fd_sc_hd__o21a_1
X_0975_ _1840_/A _1840_/B _1774_/D _2129_/Q VGND VGND VPWR VPWR _0976_/B sky130_fd_sc_hd__nor4_2
XFILLER_10_29 VGND VGND VPWR VPWR sky130_fd_sc_hd__fill_2
X_1527_ _1609_/A _1609_/B _1527_/C VGND VGND VPWR VPWR _1898_/D sky130_fd_sc_hd__nor3_1
XTAP_TAPCELL_ROW_57_418 VGND VPWR sky130_fd_sc_hd__tapvpwrvgnd_1
X_1458_ _1458_/A1 _2093_/Q _1495_/B1 _1457_/X VGND VGND VPWR VPWR _1960_/D sky130_fd_sc_hd__o31a_1
X_1389_ _2087_/Q _1448_/A2 _1448_/B1 _2071_/Q VGND VGND VPWR VPWR _1389_/Y sky130_fd_sc_hd__o22ai_1
XTAP_TAPCELL_ROW_40_329 VGND VPWR sky130_fd_sc_hd__tapvpwrvgnd_1
XFILLER_33_106 VGND VGND VPWR VPWR sky130_fd_sc_hd__fill_1
XFILLER_2_63 VGND VGND VPWR VPWR sky130_fd_sc_hd__decap_3
XFILLER_2_85 VGND VGND VPWR VPWR sky130_fd_sc_hd__decap_3
XFILLER_49_261 VGND VGND VPWR VPWR sky130_fd_sc_hd__decap_3
X_1312_ _2058_/Q _1661_/B1 _1311_/Y VGND VGND VPWR VPWR _2195_/D sky130_fd_sc_hd__a21o_1
X_1243_ _2184_/Q _2219_/Q VGND VGND VPWR VPWR _1253_/B sky130_fd_sc_hd__xor2_1
X_1174_ _1386_/S _2176_/Q VGND VGND VPWR VPWR _1174_/Y sky130_fd_sc_hd__nor2b_1
X_0958_ _1656_/B _1008_/B _1652_/B _1652_/C VGND VGND VPWR VPWR _0958_/Y sky130_fd_sc_hd__nor4_1
XFILLER_46_47 VGND VGND VPWR VPWR sky130_fd_sc_hd__fill_1
Xmax_cap37 _1782_/S VGND VGND VPWR VPWR _1781_/S sky130_fd_sc_hd__buf_2
XFILLER_16_9 VGND VGND VPWR VPWR sky130_fd_sc_hd__fill_1
XFILLER_61_201 VGND VGND VPWR VPWR sky130_fd_sc_hd__fill_2
XFILLER_61_223 VGND VGND VPWR VPWR sky130_fd_sc_hd__fill_1
X_1930_ clkload8/A _1930_/D _1955_/DE VGND VGND VPWR VPWR _1930_/Q sky130_fd_sc_hd__edfxtp_1
X_1861_ _1721_/A _2088_/Q _1861_/S VGND VGND VPWR VPWR _2088_/D sky130_fd_sc_hd__mux2_1
X_1792_ _1840_/A _1840_/B _1792_/C VGND VGND VPWR VPWR wire12/A sky130_fd_sc_hd__nand3b_1
X_1226_ _1240_/A _2193_/Q _1225_/Y _1297_/A2 VGND VGND VPWR VPWR _1226_/X sky130_fd_sc_hd__a211o_1
X_1157_ _1210_/A _2170_/Q _1270_/B1 VGND VGND VPWR VPWR _1157_/Y sky130_fd_sc_hd__o21ai_0
X_1088_ _2204_/Q _2175_/Q VGND VGND VPWR VPWR _1095_/B sky130_fd_sc_hd__xor2_1
XTAP_TAPCELL_ROW_7_168 VGND VPWR sky130_fd_sc_hd__tapvpwrvgnd_1
XFILLER_7_157 VGND VGND VPWR VPWR sky130_fd_sc_hd__fill_1
XFILLER_19_220 VGND VGND VPWR VPWR sky130_fd_sc_hd__decap_4
XFILLER_19_242 VGND VGND VPWR VPWR sky130_fd_sc_hd__decap_3
X_1011_ _0997_/Y _1007_/Y _1013_/B _1652_/B VGND VGND VPWR VPWR _1035_/A sky130_fd_sc_hd__o211a_1
X_2060_ _2230_/CLK _2060_/D fanout66/X VGND VGND VPWR VPWR _2060_/Q sky130_fd_sc_hd__dfstp_2
X_1913_ clkload0/A _1913_/D VGND VGND VPWR VPWR _1913_/Q sky130_fd_sc_hd__dfxtp_1
XTAP_TAPCELL_ROW_12_192 VGND VPWR sky130_fd_sc_hd__tapvpwrvgnd_1
X_1844_ _2073_/Q _0972_/A _1844_/S VGND VGND VPWR VPWR _2073_/D sky130_fd_sc_hd__mux2_1
X_1775_ _1719_/B _2014_/Q _1782_/S VGND VGND VPWR VPWR _2014_/D sky130_fd_sc_hd__mux2_1
XTAP_TAPCELL_ROW_4_149 VGND VPWR sky130_fd_sc_hd__tapvpwrvgnd_1
X_2189_ _2224_/CLK _2189_/D VGND VGND VPWR VPWR _2189_/Q sky130_fd_sc_hd__dfxtp_1
X_1209_ _2010_/Q _1270_/B1 _1208_/X VGND VGND VPWR VPWR _2203_/D sky130_fd_sc_hd__o21a_1
XTAP_TAPCELL_ROW_26_262 VGND VPWR sky130_fd_sc_hd__tapvpwrvgnd_1
X_1560_ _1600_/A _1333_/X VGND VGND VPWR VPWR _1562_/C sky130_fd_sc_hd__nor2b_1
XFILLER_12_3 VGND VGND VPWR VPWR sky130_fd_sc_hd__fill_2
X_2112_ clkload1/A _2112_/D load_slew60/X VGND VGND VPWR VPWR _2112_/Q sky130_fd_sc_hd__dfrtp_1
X_1491_ _1458_/A1 _0978_/A _0976_/Y _0973_/A VGND VGND VPWR VPWR _2138_/D sky130_fd_sc_hd__o2bb2ai_1
XTAP_TAPCELL_ROW_49_376 VGND VPWR sky130_fd_sc_hd__tapvpwrvgnd_1
Xfanout19 _0988_/X VGND VGND VPWR VPWR _1552_/B1 sky130_fd_sc_hd__clkdlybuf4s50_1
X_2043_ _2223_/CLK _2043_/D fanout91/X VGND VGND VPWR VPWR _2043_/Q sky130_fd_sc_hd__dfrtp_1
X_1827_ _0969_/A _2059_/Q _1828_/S VGND VGND VPWR VPWR _2059_/D sky130_fd_sc_hd__mux2_1
X_1758_ _1824_/A0 _2000_/Q wire39/A VGND VGND VPWR VPWR _2000_/D sky130_fd_sc_hd__mux2_1
X_1689_ _1976_/Q _1673_/X _1674_/Y _1688_/Y VGND VGND VPWR VPWR _1976_/D sky130_fd_sc_hd__a2bb2oi_1
XFILLER_9_219 VGND VGND VPWR VPWR sky130_fd_sc_hd__fill_1
XTAP_TAPCELL_ROW_0_130 VGND VPWR sky130_fd_sc_hd__tapvpwrvgnd_1
XFILLER_21_281 VGND VGND VPWR VPWR sky130_fd_sc_hd__decap_4
X_0991_ input2/X _2256_/Z VGND VGND VPWR VPWR _0991_/Y sky130_fd_sc_hd__nor2b_1
Xfanout209 _1961_/Q VGND VGND VPWR VPWR _1186_/A sky130_fd_sc_hd__clkdlybuf4s50_1
X_1612_ _1612_/A _1632_/B _1612_/C VGND VGND VPWR VPWR _1612_/Y sky130_fd_sc_hd__nor3_1
X_1543_ _1634_/A _1634_/B _1543_/C VGND VGND VPWR VPWR _1902_/D sky130_fd_sc_hd__nor3_1
X_1474_ _1773_/C _2126_/Q _1473_/Y VGND VGND VPWR VPWR _2126_/D sky130_fd_sc_hd__a21oi_1
XFILLER_39_167 VGND VGND VPWR VPWR sky130_fd_sc_hd__fill_1
X_2026_ _2219_/CLK _2026_/D _2050_/SET_B VGND VGND VPWR VPWR _2026_/Q sky130_fd_sc_hd__dfrtp_1
Xhold241 _2149_/Q VGND VGND VPWR VPWR _2150_/D sky130_fd_sc_hd__dlygate4sd3_1
Xhold252 _2155_/Q VGND VGND VPWR VPWR _2156_/D sky130_fd_sc_hd__dlygate4sd3_1
Xhold263 _1900_/Q VGND VGND VPWR VPWR hold263/X sky130_fd_sc_hd__dlygate4sd3_1
Xhold285 _1895_/Q VGND VGND VPWR VPWR hold285/X sky130_fd_sc_hd__dlygate4sd3_1
Xhold274 _1920_/Q VGND VGND VPWR VPWR hold274/X sky130_fd_sc_hd__dlygate4sd3_1
XFILLER_30_71 VGND VGND VPWR VPWR sky130_fd_sc_hd__fill_1
X_1190_ _1392_/S _2213_/Q _1189_/Y _1324_/A2 VGND VGND VPWR VPWR _1190_/X sky130_fd_sc_hd__a211o_1
X_0974_ _1840_/A _1840_/B _1858_/A VGND VGND VPWR VPWR _1774_/B sky130_fd_sc_hd__nor3b_1
X_1526_ _1898_/Q _1607_/B _1525_/Y VGND VGND VPWR VPWR _1527_/C sky130_fd_sc_hd__a21oi_1
X_1457_ _1604_/A _1664_/B _1944_/Q _2077_/Q _1457_/B2 VGND VGND VPWR VPWR _1457_/X
+ sky130_fd_sc_hd__o32a_1
XFILLER_35_38 VGND VGND VPWR VPWR sky130_fd_sc_hd__fill_1
X_1388_ _1388_/A _1388_/B _1388_/C VGND VGND VPWR VPWR _1388_/X sky130_fd_sc_hd__xnor3_1
X_2009_ _2221_/CLK _2009_/D fanout89/X VGND VGND VPWR VPWR _2009_/Q sky130_fd_sc_hd__dfstp_2
XFILLER_58_262 VGND VGND VPWR VPWR sky130_fd_sc_hd__decap_3
XFILLER_18_148 VGND VGND VPWR VPWR sky130_fd_sc_hd__fill_1
X_1311_ _1416_/S _1309_/X _1310_/Y VGND VGND VPWR VPWR _1311_/Y sky130_fd_sc_hd__a21oi_1
XFILLER_2_97 VGND VGND VPWR VPWR sky130_fd_sc_hd__fill_1
XPHY_EDGE_ROW_10_Right_10 VGND VGND VPWR VPWR sky130_fd_sc_hd__decap_3
X_1242_ _2021_/Q _1300_/B1 _1241_/X VGND VGND VPWR VPWR _2214_/D sky130_fd_sc_hd__o21a_1
X_1173_ _2030_/Q _1285_/B1 _1172_/X VGND VGND VPWR VPWR _2223_/D sky130_fd_sc_hd__o21a_1
XFILLER_32_195 VGND VGND VPWR VPWR sky130_fd_sc_hd__fill_1
X_0957_ _1006_/B _1044_/A _1045_/C VGND VGND VPWR VPWR _1656_/C sky130_fd_sc_hd__nand3_1
X_1509_ _1615_/A _1352_/X _1508_/Y VGND VGND VPWR VPWR _1509_/Y sky130_fd_sc_hd__a21oi_1
Xmax_cap27 _1861_/S VGND VGND VPWR VPWR _1866_/S sky130_fd_sc_hd__buf_2
XFILLER_36_92 VGND VGND VPWR VPWR sky130_fd_sc_hd__fill_2
X_1860_ _0968_/A _2087_/Q _1861_/S VGND VGND VPWR VPWR _2087_/D sky130_fd_sc_hd__mux2_1
X_1791_ _2029_/Q _1820_/A0 _1791_/S VGND VGND VPWR VPWR _2029_/D sky130_fd_sc_hd__mux2_1
XFILLER_42_3 VGND VGND VPWR VPWR sky130_fd_sc_hd__fill_1
XFILLER_16_18 VGND VGND VPWR VPWR sky130_fd_sc_hd__fill_1
XFILLER_16_29 VGND VGND VPWR VPWR sky130_fd_sc_hd__fill_1
XFILLER_52_202 VGND VGND VPWR VPWR sky130_fd_sc_hd__decap_3
X_1225_ _1240_/A _2225_/Q VGND VGND VPWR VPWR _1225_/Y sky130_fd_sc_hd__nor2b_1
X_1156_ _2202_/Q _1210_/A VGND VGND VPWR VPWR _1156_/Y sky130_fd_sc_hd__nor2b_1
X_1087_ _1267_/A2 _1086_/Y _1083_/Y VGND VGND VPWR VPWR _2170_/D sky130_fd_sc_hd__o21ai_0
X_1989_ _2166_/CLK _1989_/D fanout87/X VGND VGND VPWR VPWR _1989_/Q sky130_fd_sc_hd__dfrtp_1
XFILLER_7_169 VGND VGND VPWR VPWR sky130_fd_sc_hd__decap_3
X_1010_ _1017_/B _1022_/B _1009_/B _1016_/D VGND VGND VPWR VPWR _1010_/Y sky130_fd_sc_hd__a22oi_1
XFILLER_8_85 VGND VGND VPWR VPWR sky130_fd_sc_hd__fill_2
X_1912_ clkload6/A _1912_/D VGND VGND VPWR VPWR _1912_/Q sky130_fd_sc_hd__dfxtp_1
X_1843_ _2072_/Q _1721_/A _1844_/S VGND VGND VPWR VPWR _2072_/D sky130_fd_sc_hd__mux2_1
XTAP_TAPCELL_ROW_12_193 VGND VPWR sky130_fd_sc_hd__tapvpwrvgnd_1
X_1774_ _2129_/Q _1774_/B _1821_/C _1774_/D VGND VGND VPWR VPWR _1782_/S sky130_fd_sc_hd__nand4b_1
XFILLER_27_28 VGND VGND VPWR VPWR sky130_fd_sc_hd__fill_1
X_1208_ _1356_/S _2187_/Q _1207_/Y _1267_/A2 VGND VGND VPWR VPWR _1208_/X sky130_fd_sc_hd__a211o_1
XFILLER_25_279 VGND VGND VPWR VPWR sky130_fd_sc_hd__fill_1
X_2188_ _2221_/CLK _2188_/D VGND VGND VPWR VPWR _2188_/Q sky130_fd_sc_hd__dfxtp_1
X_1139_ _2214_/Q _2169_/Q VGND VGND VPWR VPWR _1143_/C sky130_fd_sc_hd__xor2_1
XTAP_TAPCELL_ROW_18_219 VGND VPWR sky130_fd_sc_hd__tapvpwrvgnd_1
XFILLER_16_279 VGND VGND VPWR VPWR sky130_fd_sc_hd__decap_6
XFILLER_33_82 VGND VGND VPWR VPWR sky130_fd_sc_hd__decap_8
XTAP_TAPCELL_ROW_26_263 VGND VPWR sky130_fd_sc_hd__tapvpwrvgnd_1
X_1490_ _0969_/C _2137_/Q _1490_/S VGND VGND VPWR VPWR _2137_/D sky130_fd_sc_hd__mux2_1
X_2111_ clkload9/A _2111_/D fanout69/A VGND VGND VPWR VPWR _2111_/Q sky130_fd_sc_hd__dfrtp_1
X_2042_ _2219_/CLK _2042_/D fanout91/X VGND VGND VPWR VPWR _2042_/Q sky130_fd_sc_hd__dfrtp_1
XPHY_EDGE_ROW_8_Right_8 VGND VGND VPWR VPWR sky130_fd_sc_hd__decap_3
XTAP_TAPCELL_ROW_49_377 VGND VPWR sky130_fd_sc_hd__tapvpwrvgnd_1
XFILLER_30_260 VGND VGND VPWR VPWR sky130_fd_sc_hd__fill_1
X_1826_ _0969_/B _2058_/Q _1828_/S VGND VGND VPWR VPWR _2058_/D sky130_fd_sc_hd__mux2_1
XPHY_EDGE_ROW_39_Right_39 VGND VGND VPWR VPWR sky130_fd_sc_hd__decap_3
Xmax_cap120 _0976_/B VGND VGND VPWR VPWR _1721_/D sky130_fd_sc_hd__buf_1
X_1757_ _1718_/D _1999_/Q _1757_/S VGND VGND VPWR VPWR _1999_/D sky130_fd_sc_hd__mux2_1
X_1688_ _1975_/Q _1996_/Q _1690_/S VGND VGND VPWR VPWR _1688_/Y sky130_fd_sc_hd__mux2i_1
XTAP_TAPCELL_ROW_0_131 VGND VPWR sky130_fd_sc_hd__tapvpwrvgnd_1
XPHY_EDGE_ROW_48_Right_48 VGND VGND VPWR VPWR sky130_fd_sc_hd__decap_3
XTAP_TAPCELL_ROW_23_244 VGND VPWR sky130_fd_sc_hd__tapvpwrvgnd_1
XPHY_EDGE_ROW_57_Right_57 VGND VGND VPWR VPWR sky130_fd_sc_hd__decap_3
XTAP_TAPCELL_ROW_14_200 VGND VPWR sky130_fd_sc_hd__tapvpwrvgnd_1
XFILLER_44_81 VGND VGND VPWR VPWR sky130_fd_sc_hd__decap_3
XFILLER_8_242 VGND VGND VPWR VPWR sky130_fd_sc_hd__fill_1
XFILLER_8_253 VGND VGND VPWR VPWR sky130_fd_sc_hd__decap_6
X_0990_ hold256/X _1552_/B1 _0983_/B VGND VGND VPWR VPWR _2140_/D sky130_fd_sc_hd__o21a_1
X_1611_ _1939_/Q _1452_/A1 VGND VGND VPWR VPWR _1612_/A sky130_fd_sc_hd__nor2b_1
XFILLER_5_42 VGND VGND VPWR VPWR sky130_fd_sc_hd__decap_3
X_1542_ _1902_/Q _1617_/B _1541_/Y VGND VGND VPWR VPWR _1543_/C sky130_fd_sc_hd__a21oi_1
X_1473_ _1773_/C _2126_/Q _1478_/A VGND VGND VPWR VPWR _1473_/Y sky130_fd_sc_hd__o21bai_1
XFILLER_54_149 VGND VGND VPWR VPWR sky130_fd_sc_hd__fill_2
XTAP_TAPCELL_ROW_37_314 VGND VPWR sky130_fd_sc_hd__tapvpwrvgnd_1
X_2025_ _2219_/CLK _2025_/D _2050_/SET_B VGND VGND VPWR VPWR _2025_/Q sky130_fd_sc_hd__dfstp_2
XFILLER_24_29 VGND VGND VPWR VPWR sky130_fd_sc_hd__fill_1
Xhold242 _2147_/Q VGND VGND VPWR VPWR _2148_/D sky130_fd_sc_hd__dlygate4sd3_1
Xhold253 _1988_/Q VGND VGND VPWR VPWR _2154_/D sky130_fd_sc_hd__dlygate4sd3_1
X_1809_ _2044_/Q _1819_/A0 wire33/X VGND VGND VPWR VPWR _2044_/D sky130_fd_sc_hd__mux2_1
Xhold264 _1999_/Q VGND VGND VPWR VPWR hold264/X sky130_fd_sc_hd__dlygate4sd3_1
Xhold286 _1912_/Q VGND VGND VPWR VPWR hold286/X sky130_fd_sc_hd__dlygate4sd3_1
Xhold275 _2047_/Q VGND VGND VPWR VPWR hold275/X sky130_fd_sc_hd__dlygate4sd3_1
XFILLER_53_160 VGND VGND VPWR VPWR sky130_fd_sc_hd__fill_1
Xclkbuf_leaf_14_dclk clkbuf_leaf_2_dclk/A VGND VGND VPWR VPWR clkload4/A sky130_fd_sc_hd__clkbuf_16
X_0973_ _0973_/A _0973_/B VGND VGND VPWR VPWR _0977_/A sky130_fd_sc_hd__nand2_1
X_1525_ _1635_/A _1376_/X _1524_/Y VGND VGND VPWR VPWR _1525_/Y sky130_fd_sc_hd__a21oi_1
X_1456_ _2076_/Q _1456_/A2 _1456_/B1 _2092_/Q _1455_/X VGND VGND VPWR VPWR _1959_/D
+ sky130_fd_sc_hd__o221a_1
X_1387_ _1936_/Q _1954_/Q VGND VGND VPWR VPWR _1388_/C sky130_fd_sc_hd__xor2_1
XFILLER_35_28 VGND VGND VPWR VPWR sky130_fd_sc_hd__fill_1
X_2008_ _2223_/CLK _2008_/D _2023_/SET_B VGND VGND VPWR VPWR _2008_/Q sky130_fd_sc_hd__dfstp_2
XFILLER_1_281 VGND VGND VPWR VPWR sky130_fd_sc_hd__decap_4
XFILLER_49_241 VGND VGND VPWR VPWR sky130_fd_sc_hd__fill_1
X_1310_ _1416_/S _2211_/Q _1310_/B1 VGND VGND VPWR VPWR _1310_/Y sky130_fd_sc_hd__o21ai_0
X_1241_ _1240_/A _2198_/Q _1240_/Y _1307_/A2 VGND VGND VPWR VPWR _1241_/X sky130_fd_sc_hd__a211o_1
X_1172_ _1380_/S _2207_/Q _1171_/Y _1297_/A2 VGND VGND VPWR VPWR _1172_/X sky130_fd_sc_hd__a211o_1
XFILLER_17_193 VGND VGND VPWR VPWR sky130_fd_sc_hd__decap_4
XFILLER_32_141 VGND VGND VPWR VPWR sky130_fd_sc_hd__fill_2
X_0956_ _1629_/A _1629_/B VGND VGND VPWR VPWR _0956_/X sky130_fd_sc_hd__or2_0
X_1508_ _1615_/A _1932_/Q _1552_/B1 VGND VGND VPWR VPWR _1508_/Y sky130_fd_sc_hd__o21ai_0
X_1439_ _1624_/A _1624_/B _1935_/Q _2068_/Q _1457_/B2 VGND VGND VPWR VPWR _1439_/X
+ sky130_fd_sc_hd__o32a_1
Xclkbuf_0_dclk dclk VGND VGND VPWR VPWR clkbuf_0_dclk/X sky130_fd_sc_hd__clkbuf_16
XFILLER_11_63 VGND VGND VPWR VPWR sky130_fd_sc_hd__decap_3
XFILLER_2_3 VGND VGND VPWR VPWR sky130_fd_sc_hd__fill_1
XFILLER_14_141 VGND VGND VPWR VPWR sky130_fd_sc_hd__decap_4
XPHY_EDGE_ROW_26_Left_88 VGND VGND VPWR VPWR sky130_fd_sc_hd__decap_3
X_1790_ _2028_/Q _1819_/A0 _1791_/S VGND VGND VPWR VPWR _2028_/D sky130_fd_sc_hd__mux2_1
X_1224_ _2015_/Q _1444_/A3 _1223_/X VGND VGND VPWR VPWR _2208_/D sky130_fd_sc_hd__o21a_1
X_1155_ hold257/X _1329_/A2 _1153_/Y _1154_/Y VGND VGND VPWR VPWR _2217_/D sky130_fd_sc_hd__o2bb2ai_1
X_1086_ _1085_/X _2218_/Q _1356_/S VGND VGND VPWR VPWR _1086_/Y sky130_fd_sc_hd__mux2i_1
XFILLER_20_133 VGND VGND VPWR VPWR sky130_fd_sc_hd__decap_3
X_1988_ _2161_/CLK _1988_/D wire75/X VGND VGND VPWR VPWR _1988_/Q sky130_fd_sc_hd__dfstp_2
XFILLER_11_122 VGND VGND VPWR VPWR sky130_fd_sc_hd__decap_4
XFILLER_11_199 VGND VGND VPWR VPWR sky130_fd_sc_hd__fill_2
XFILLER_22_62 VGND VGND VPWR VPWR sky130_fd_sc_hd__decap_3
Xfanout190 _1962_/Q VGND VGND VPWR VPWR _1719_/B sky130_fd_sc_hd__clkdlybuf4s50_1
X_1911_ clkload7/A _1911_/D VGND VGND VPWR VPWR _1911_/Q sky130_fd_sc_hd__dfxtp_1
X_1842_ _2071_/Q _0968_/A _1842_/S VGND VGND VPWR VPWR _2071_/D sky130_fd_sc_hd__mux2_1
X_1773_ _2129_/Q _1821_/C _1773_/C _1774_/D VGND VGND VPWR VPWR _1792_/C sky130_fd_sc_hd__and4b_1
X_2187_ _2219_/CLK _2187_/D VGND VGND VPWR VPWR _2187_/Q sky130_fd_sc_hd__dfxtp_1
X_2256_ _2256_/A _1889_/X VGND VGND VPWR VPWR _2256_/Z sky130_fd_sc_hd__ebufn_2
X_1207_ _1207_/A _2219_/Q VGND VGND VPWR VPWR _1207_/Y sky130_fd_sc_hd__nor2b_1
X_1138_ _1459_/B _1664_/B _2004_/Q VGND VGND VPWR VPWR _1138_/Y sky130_fd_sc_hd__o21ai_0
X_1069_ _1063_/Y _1066_/X _1068_/Y VGND VGND VPWR VPWR _1069_/Y sky130_fd_sc_hd__o21ai_0
XFILLER_4_107 VGND VGND VPWR VPWR sky130_fd_sc_hd__fill_1
XFILLER_16_214 VGND VGND VPWR VPWR sky130_fd_sc_hd__fill_2
XFILLER_33_72 VGND VGND VPWR VPWR sky130_fd_sc_hd__decap_3
XTAP_TAPCELL_ROW_49_378 VGND VPWR sky130_fd_sc_hd__tapvpwrvgnd_1
X_2110_ _2208_/CLK _2110_/D fanout80/X VGND VGND VPWR VPWR _2110_/Q sky130_fd_sc_hd__dfrtp_1
X_2041_ _2219_/CLK _2041_/D fanout83/X VGND VGND VPWR VPWR _2041_/Q sky130_fd_sc_hd__dfrtp_1
XFILLER_30_283 VGND VGND VPWR VPWR sky130_fd_sc_hd__fill_2
XPHY_EDGE_ROW_29_Left_91 VGND VGND VPWR VPWR sky130_fd_sc_hd__decap_3
XTAP_TAPCELL_ROW_32_289 VGND VPWR sky130_fd_sc_hd__tapvpwrvgnd_1
Xmax_cap121 _0969_/Y VGND VGND VPWR VPWR _0971_/B sky130_fd_sc_hd__clkdlybuf4s25_1
X_1825_ _0972_/A _2057_/Q _1828_/S VGND VGND VPWR VPWR _2057_/D sky130_fd_sc_hd__mux2_1
X_1756_ _1719_/B _1998_/Q _1757_/S VGND VGND VPWR VPWR _1998_/D sky130_fd_sc_hd__mux2_1
XPHY_EDGE_ROW_13_Left_75 VGND VGND VPWR VPWR sky130_fd_sc_hd__decap_3
X_1687_ _1975_/Q _1673_/X _1687_/B1 _1686_/Y VGND VGND VPWR VPWR _1975_/D sky130_fd_sc_hd__a2bb2oi_1
XFILLER_57_158 VGND VGND VPWR VPWR sky130_fd_sc_hd__fill_1
XTAP_TAPCELL_ROW_0_132 VGND VPWR sky130_fd_sc_hd__tapvpwrvgnd_1
XTAP_TAPCELL_ROW_23_245 VGND VPWR sky130_fd_sc_hd__tapvpwrvgnd_1
XTAP_TAPCELL_ROW_14_201 VGND VPWR sky130_fd_sc_hd__tapvpwrvgnd_1
XTAP_TAPCELL_ROW_46_359 VGND VPWR sky130_fd_sc_hd__tapvpwrvgnd_1
X_1610_ _1610_/A _1394_/X VGND VGND VPWR VPWR _1612_/C sky130_fd_sc_hd__nor2b_1
X_1541_ _1615_/A _1400_/X _1540_/Y VGND VGND VPWR VPWR _1541_/Y sky130_fd_sc_hd__a21oi_1
X_1472_ _1773_/C _2139_/Q VGND VGND VPWR VPWR _1478_/A sky130_fd_sc_hd__nor2b_1
XTAP_TAPCELL_ROW_37_315 VGND VPWR sky130_fd_sc_hd__tapvpwrvgnd_1
X_2024_ _2223_/CLK _2024_/D _2023_/SET_B VGND VGND VPWR VPWR _2024_/Q sky130_fd_sc_hd__dfrtp_1
Xdigital_top VGND VGND VPWR VPWR digital_top/HI duio_oe[0] sky130_fd_sc_hd__conb_1
Xhold243 _2146_/Q VGND VGND VPWR VPWR _2147_/D sky130_fd_sc_hd__dlygate4sd3_1
Xhold254 _2165_/Q VGND VGND VPWR VPWR _2166_/D sky130_fd_sc_hd__dlygate4sd3_1
Xhold265 _2048_/Q VGND VGND VPWR VPWR hold265/X sky130_fd_sc_hd__dlygate4sd3_1
Xhold287 _2002_/Q VGND VGND VPWR VPWR hold287/X sky130_fd_sc_hd__dlygate4sd3_1
Xhold276 _1898_/Q VGND VGND VPWR VPWR hold276/X sky130_fd_sc_hd__dlygate4sd3_1
X_1808_ _2043_/Q _1818_/A0 wire33/X VGND VGND VPWR VPWR _2043_/D sky130_fd_sc_hd__mux2_1
X_1739_ _2106_/Q wire97/X _1745_/B _2098_/Q VGND VGND VPWR VPWR _1739_/Y sky130_fd_sc_hd__a22oi_1
XFILLER_14_63 VGND VGND VPWR VPWR sky130_fd_sc_hd__fill_1
XFILLER_5_246 VGND VGND VPWR VPWR sky130_fd_sc_hd__decap_4
XTAP_TAPCELL_ROW_51_384 VGND VPWR sky130_fd_sc_hd__tapvpwrvgnd_1
XFILLER_30_62 VGND VGND VPWR VPWR sky130_fd_sc_hd__fill_1
XTAP_TAPCELL_ROW_42_340 VGND VPWR sky130_fd_sc_hd__tapvpwrvgnd_1
X_0972_ _0972_/A _1721_/A _0972_/C _0968_/A VGND VGND VPWR VPWR _0973_/B sky130_fd_sc_hd__or4b_1
X_1524_ _1635_/A _1936_/Q _1556_/B1 VGND VGND VPWR VPWR _1524_/Y sky130_fd_sc_hd__o21ai_0
X_1455_ _1614_/A _1614_/B _1943_/Q VGND VGND VPWR VPWR _1455_/X sky130_fd_sc_hd__or3_1
X_1386_ _2192_/Q _2176_/Q _1386_/S VGND VGND VPWR VPWR _1388_/B sky130_fd_sc_hd__mux2i_1
XFILLER_50_131 VGND VGND VPWR VPWR sky130_fd_sc_hd__fill_1
X_2007_ _2223_/CLK _2007_/D _2023_/SET_B VGND VGND VPWR VPWR _2007_/Q sky130_fd_sc_hd__dfstp_2
XFILLER_50_197 VGND VGND VPWR VPWR sky130_fd_sc_hd__fill_1
XFILLER_2_249 VGND VGND VPWR VPWR sky130_fd_sc_hd__decap_3
XFILLER_18_139 VGND VGND VPWR VPWR sky130_fd_sc_hd__fill_1
XTAP_TAPCELL_ROW_56_410 VGND VPWR sky130_fd_sc_hd__tapvpwrvgnd_1
XFILLER_25_84 VGND VGND VPWR VPWR sky130_fd_sc_hd__fill_1
XFILLER_41_197 VGND VGND VPWR VPWR sky130_fd_sc_hd__fill_2
XPHY_EDGE_ROW_47_Left_109 VGND VGND VPWR VPWR sky130_fd_sc_hd__decap_3
XFILLER_2_33 VGND VGND VPWR VPWR sky130_fd_sc_hd__fill_1
X_1240_ _1240_/A _2230_/Q VGND VGND VPWR VPWR _1240_/Y sky130_fd_sc_hd__nor2b_1
X_1171_ _1386_/S _2175_/Q VGND VGND VPWR VPWR _1171_/Y sky130_fd_sc_hd__nor2b_1
XPHY_EDGE_ROW_56_Left_118 VGND VGND VPWR VPWR sky130_fd_sc_hd__decap_3
XFILLER_32_197 VGND VGND VPWR VPWR sky130_fd_sc_hd__decap_4
X_0955_ _1629_/A _1629_/B VGND VGND VPWR VPWR _0955_/Y sky130_fd_sc_hd__nor2_1
X_1507_ _1639_/A _1639_/B _1507_/C VGND VGND VPWR VPWR _1893_/D sky130_fd_sc_hd__nor3_1
X_1438_ _1620_/A _2083_/Q _0983_/B _1437_/X VGND VGND VPWR VPWR _1950_/D sky130_fd_sc_hd__o31a_1
X_1369_ _1933_/Q _1951_/Q VGND VGND VPWR VPWR _1370_/C sky130_fd_sc_hd__xor2_1
XFILLER_36_83 VGND VGND VPWR VPWR sky130_fd_sc_hd__fill_1
XPHY_EDGE_ROW_1_Left_63 VGND VGND VPWR VPWR sky130_fd_sc_hd__decap_3
XFILLER_14_197 VGND VGND VPWR VPWR sky130_fd_sc_hd__decap_6
XFILLER_37_201 VGND VGND VPWR VPWR sky130_fd_sc_hd__fill_2
X_1223_ _1386_/S _2192_/Q _1222_/Y _1297_/A2 VGND VGND VPWR VPWR _1223_/X sky130_fd_sc_hd__a211o_1
X_1154_ _1344_/S _2169_/Q _1300_/B1 VGND VGND VPWR VPWR _1154_/Y sky130_fd_sc_hd__o21ai_0
X_1085_ _2186_/Q _1085_/B _1089_/B VGND VGND VPWR VPWR _1085_/X sky130_fd_sc_hd__xnor3_1
X_1987_ _2161_/CLK _1987_/D fanout76/X VGND VGND VPWR VPWR _1987_/Q sky130_fd_sc_hd__dfrtp_1
XFILLER_51_281 VGND VGND VPWR VPWR sky130_fd_sc_hd__decap_4
Xwire93 wire94/X VGND VGND VPWR VPWR wire93/X sky130_fd_sc_hd__clkbuf_2
XFILLER_19_234 VGND VGND VPWR VPWR sky130_fd_sc_hd__fill_1
XTAP_TAPCELL_ROW_6_160 VGND VPWR sky130_fd_sc_hd__tapvpwrvgnd_1
Xfanout180 _1967_/Q VGND VGND VPWR VPWR _1818_/A0 sky130_fd_sc_hd__clkdlybuf4s50_1
Xfanout191 _1410_/S VGND VGND VPWR VPWR _1022_/C sky130_fd_sc_hd__clkdlybuf4s50_1
X_1910_ clkload7/A _1910_/D VGND VGND VPWR VPWR _1910_/Q sky130_fd_sc_hd__dfxtp_1
X_1841_ _2070_/Q _1812_/A _1848_/S VGND VGND VPWR VPWR _2070_/D sky130_fd_sc_hd__mux2_1
X_1772_ _1820_/A0 _2013_/Q wire38/X VGND VGND VPWR VPWR _2013_/D sky130_fd_sc_hd__mux2_1
X_2186_ _2221_/CLK _2186_/D VGND VGND VPWR VPWR _2186_/Q sky130_fd_sc_hd__dfxtp_1
X_1206_ _2009_/Q _1270_/B1 _1205_/X VGND VGND VPWR VPWR _2202_/D sky130_fd_sc_hd__o21a_1
X_1137_ _1661_/B1 _1136_/Y _1133_/Y VGND VGND VPWR VPWR _2180_/D sky130_fd_sc_hd__o21ai_0
XFILLER_33_281 VGND VGND VPWR VPWR sky130_fd_sc_hd__decap_4
XFILLER_40_218 VGND VGND VPWR VPWR sky130_fd_sc_hd__fill_1
X_1068_ _1067_/Y _1247_/A _1248_/B VGND VGND VPWR VPWR _1068_/Y sky130_fd_sc_hd__a21oi_1
XFILLER_4_119 VGND VGND VPWR VPWR sky130_fd_sc_hd__fill_2
XFILLER_16_237 VGND VGND VPWR VPWR sky130_fd_sc_hd__decap_4
XFILLER_3_196 VGND VGND VPWR VPWR sky130_fd_sc_hd__fill_1
X_2040_ _2223_/CLK _2040_/D fanout83/X VGND VGND VPWR VPWR _2040_/Q sky130_fd_sc_hd__dfstp_2
XFILLER_15_281 VGND VGND VPWR VPWR sky130_fd_sc_hd__decap_4
Xmax_cap100 _1686_/S VGND VGND VPWR VPWR _1690_/S sky130_fd_sc_hd__clkbuf_2
X_1824_ _1824_/A0 _2056_/Q _1828_/S VGND VGND VPWR VPWR _2056_/D sky130_fd_sc_hd__mux2_1
X_1755_ _1774_/D _2129_/Q _1774_/B _1821_/C VGND VGND VPWR VPWR _1757_/S sky130_fd_sc_hd__nand4b_1
X_1686_ _1974_/Q _1995_/Q _1686_/S VGND VGND VPWR VPWR _1686_/Y sky130_fd_sc_hd__mux2i_1
XTAP_TAPCELL_ROW_0_133 VGND VPWR sky130_fd_sc_hd__tapvpwrvgnd_1
X_2169_ _2223_/CLK _2169_/D VGND VGND VPWR VPWR _2169_/Q sky130_fd_sc_hd__dfxtp_1
XFILLER_21_262 VGND VGND VPWR VPWR sky130_fd_sc_hd__fill_2
XTAP_TAPCELL_ROW_23_246 VGND VPWR sky130_fd_sc_hd__tapvpwrvgnd_1
XFILLER_0_166 VGND VGND VPWR VPWR sky130_fd_sc_hd__fill_2
XFILLER_48_126 VGND VGND VPWR VPWR sky130_fd_sc_hd__fill_2
XTAP_TAPCELL_ROW_14_202 VGND VPWR sky130_fd_sc_hd__tapvpwrvgnd_1
XPHY_EDGE_ROW_30_Left_92 VGND VGND VPWR VPWR sky130_fd_sc_hd__decap_3
X_1540_ _1615_/A _1940_/Q _1552_/B1 VGND VGND VPWR VPWR _1540_/Y sky130_fd_sc_hd__o21ai_0
X_1471_ _1773_/C _1840_/A VGND VGND VPWR VPWR _1783_/B sky130_fd_sc_hd__nand2_1
XTAP_TAPCELL_ROW_37_316 VGND VPWR sky130_fd_sc_hd__tapvpwrvgnd_1
X_2023_ _2223_/CLK _2023_/D _2023_/SET_B VGND VGND VPWR VPWR _2023_/Q sky130_fd_sc_hd__dfstp_2
X_1807_ _2042_/Q _1817_/A0 wire33/X VGND VGND VPWR VPWR _2042_/D sky130_fd_sc_hd__mux2_1
Xhold244 _2152_/Q VGND VGND VPWR VPWR _2153_/D sky130_fd_sc_hd__dlygate4sd3_1
Xhold255 _2164_/Q VGND VGND VPWR VPWR _2165_/D sky130_fd_sc_hd__dlygate4sd3_1
Xhold266 _2028_/Q VGND VGND VPWR VPWR hold266/X sky130_fd_sc_hd__dlygate4sd3_1
Xhold288 _1918_/Q VGND VGND VPWR VPWR hold288/X sky130_fd_sc_hd__dlygate4sd3_1
Xhold277 _1922_/Q VGND VGND VPWR VPWR hold277/X sky130_fd_sc_hd__dlygate4sd3_1
X_1738_ _2122_/Q _1746_/A2 wire93/X _2114_/Q VGND VGND VPWR VPWR _1738_/Y sky130_fd_sc_hd__a22oi_1
X_1669_ _1817_/A0 _1981_/Q _1669_/S VGND VGND VPWR VPWR _1966_/D sky130_fd_sc_hd__mux2_1
XFILLER_53_184 VGND VGND VPWR VPWR sky130_fd_sc_hd__fill_1
XFILLER_5_225 VGND VGND VPWR VPWR sky130_fd_sc_hd__fill_2
XTAP_TAPCELL_ROW_51_385 VGND VPWR sky130_fd_sc_hd__tapvpwrvgnd_1
XFILLER_30_85 VGND VGND VPWR VPWR sky130_fd_sc_hd__decap_3
XFILLER_44_195 VGND VGND VPWR VPWR sky130_fd_sc_hd__fill_1
XTAP_TAPCELL_ROW_42_341 VGND VPWR sky130_fd_sc_hd__tapvpwrvgnd_1
X_0971_ _1719_/B _0971_/B VGND VGND VPWR VPWR _0972_/C sky130_fd_sc_hd__nand2_1
X_1523_ _1614_/A _1614_/B _1523_/C VGND VGND VPWR VPWR _1897_/D sky130_fd_sc_hd__nor3_1
X_1454_ _2075_/Q _1456_/A2 _1456_/B1 _2091_/Q _1453_/X VGND VGND VPWR VPWR _1958_/D
+ sky130_fd_sc_hd__o221a_1
X_1385_ _1937_/Q _1930_/Q VGND VGND VPWR VPWR _1388_/A sky130_fd_sc_hd__nand2_1
XFILLER_35_173 VGND VGND VPWR VPWR sky130_fd_sc_hd__decap_3
X_2006_ clkload3/A _2006_/D fanout66/X VGND VGND VPWR VPWR _2006_/Q sky130_fd_sc_hd__dfrtp_1
XTAP_TAPCELL_ROW_56_411 VGND VPWR sky130_fd_sc_hd__tapvpwrvgnd_1
XFILLER_41_176 VGND VGND VPWR VPWR sky130_fd_sc_hd__decap_3
XFILLER_49_232 VGND VGND VPWR VPWR sky130_fd_sc_hd__fill_2
X_1170_ hold258/X _1282_/A2 _1168_/Y _1169_/Y VGND VGND VPWR VPWR _2222_/D sky130_fd_sc_hd__o2bb2ai_1
X_0954_ _2046_/Q VGND VGND VPWR VPWR _0954_/Y sky130_fd_sc_hd__inv_1
X_1506_ _1893_/Q _1637_/B _1505_/Y VGND VGND VPWR VPWR _1507_/C sky130_fd_sc_hd__a21oi_1
X_1437_ _1634_/A _1634_/B _1934_/Q _2067_/Q _1451_/B2 VGND VGND VPWR VPWR _1437_/X
+ sky130_fd_sc_hd__o32a_1
X_1368_ _2189_/Q _2173_/Q _1368_/S VGND VGND VPWR VPWR _1370_/B sky130_fd_sc_hd__mux2i_1
X_1299_ _2177_/Q _1299_/B _1304_/B VGND VGND VPWR VPWR _1299_/X sky130_fd_sc_hd__xor3_1
XFILLER_23_165 VGND VGND VPWR VPWR sky130_fd_sc_hd__decap_3
XFILLER_23_176 VGND VGND VPWR VPWR sky130_fd_sc_hd__decap_3
XFILLER_11_10 VGND VGND VPWR VPWR sky130_fd_sc_hd__fill_1
XFILLER_52_61 VGND VGND VPWR VPWR sky130_fd_sc_hd__fill_1
X_1222_ _1386_/S _2224_/Q VGND VGND VPWR VPWR _1222_/Y sky130_fd_sc_hd__nor2b_1
X_1153_ _2201_/Q _1344_/S VGND VGND VPWR VPWR _1153_/Y sky130_fd_sc_hd__nor2b_1
X_1084_ _2203_/Q _2174_/Q VGND VGND VPWR VPWR _1089_/B sky130_fd_sc_hd__xor2_1
XFILLER_60_282 VGND VGND VPWR VPWR sky130_fd_sc_hd__decap_3
X_1986_ clkload9/A _1986_/D fanout73/X VGND VGND VPWR VPWR _1986_/Q sky130_fd_sc_hd__dfrtp_1
Xwire94 wire94/A VGND VGND VPWR VPWR wire94/X sky130_fd_sc_hd__clkbuf_2
XFILLER_11_146 VGND VGND VPWR VPWR sky130_fd_sc_hd__fill_1
XTAP_TAPCELL_ROW_6_161 VGND VPWR sky130_fd_sc_hd__tapvpwrvgnd_1
Xfanout170 _1458_/A1 VGND VGND VPWR VPWR _1600_/A sky130_fd_sc_hd__clkdlybuf4s50_1
Xfanout181 _1966_/Q VGND VGND VPWR VPWR _0969_/B sky130_fd_sc_hd__clkdlybuf4s50_1
Xfanout192 _1186_/A VGND VGND VPWR VPWR _1410_/S sky130_fd_sc_hd__clkdlybuf4s50_1
XFILLER_8_33 VGND VGND VPWR VPWR sky130_fd_sc_hd__fill_2
XTAP_TAPCELL_ROW_29_274 VGND VPWR sky130_fd_sc_hd__tapvpwrvgnd_1
X_1840_ _1840_/A _1840_/B _1840_/C _1840_/D VGND VGND VPWR VPWR _1842_/S sky130_fd_sc_hd__nor4_2
XFILLER_8_44 VGND VGND VPWR VPWR sky130_fd_sc_hd__fill_1
X_1771_ _1819_/A0 _2012_/Q wire38/X VGND VGND VPWR VPWR _2012_/D sky130_fd_sc_hd__mux2_1
XFILLER_40_208 VGND VGND VPWR VPWR sky130_fd_sc_hd__decap_3
X_2185_ _2223_/CLK _2185_/D VGND VGND VPWR VPWR _2185_/Q sky130_fd_sc_hd__dfxtp_1
X_1205_ _1207_/A _2186_/Q _1204_/Y _1267_/A2 VGND VGND VPWR VPWR _1205_/X sky130_fd_sc_hd__a211o_1
X_1136_ _1135_/X _2228_/Q _1248_/B VGND VGND VPWR VPWR _1136_/Y sky130_fd_sc_hd__mux2i_1
X_1067_ _1062_/A _1062_/B _1066_/X VGND VGND VPWR VPWR _1067_/Y sky130_fd_sc_hd__a21boi_0
X_1969_ _2166_/CLK _1969_/D load_slew79/X VGND VGND VPWR VPWR _1969_/Q sky130_fd_sc_hd__dfrtp_1
XFILLER_16_249 VGND VGND VPWR VPWR sky130_fd_sc_hd__decap_3
XFILLER_17_64 VGND VGND VPWR VPWR sky130_fd_sc_hd__fill_1
XFILLER_24_260 VGND VGND VPWR VPWR sky130_fd_sc_hd__decap_4
Xclkbuf_leaf_17_dclk clkbuf_leaf_2_dclk/A VGND VGND VPWR VPWR clkload7/A sky130_fd_sc_hd__clkbuf_16
XFILLER_15_271 VGND VGND VPWR VPWR sky130_fd_sc_hd__fill_2
X_1823_ _0968_/A _2055_/Q _1829_/S VGND VGND VPWR VPWR _2055_/D sky130_fd_sc_hd__mux2_1
Xmax_cap101 _1674_/Y VGND VGND VPWR VPWR _1687_/B1 sky130_fd_sc_hd__clkbuf_2
X_1754_ _2131_/Q _1754_/B _1858_/D _2130_/Q VGND VGND VPWR VPWR _1821_/C sky130_fd_sc_hd__and4b_1
X_1685_ _1974_/Q _1673_/X _1687_/B1 _1684_/Y VGND VGND VPWR VPWR _1974_/D sky130_fd_sc_hd__a2bb2oi_1
XFILLER_13_208 VGND VGND VPWR VPWR sky130_fd_sc_hd__decap_3
XFILLER_21_230 VGND VGND VPWR VPWR sky130_fd_sc_hd__decap_4
X_2168_ _2223_/CLK _2168_/D VGND VGND VPWR VPWR _2168_/Q sky130_fd_sc_hd__dfxtp_1
X_2099_ clkload6/A _2099_/D load_slew58/X VGND VGND VPWR VPWR _2099_/Q sky130_fd_sc_hd__dfrtp_1
X_1119_ _2210_/Q _2181_/Q VGND VGND VPWR VPWR _1124_/B sky130_fd_sc_hd__xor2_1
XPHY_EDGE_ROW_17_Right_17 VGND VGND VPWR VPWR sky130_fd_sc_hd__decap_3
XTAP_TAPCELL_ROW_23_247 VGND VPWR sky130_fd_sc_hd__tapvpwrvgnd_1
XFILLER_0_145 VGND VGND VPWR VPWR sky130_fd_sc_hd__fill_1
XPHY_EDGE_ROW_26_Right_26 VGND VGND VPWR VPWR sky130_fd_sc_hd__decap_3
XFILLER_28_85 VGND VGND VPWR VPWR sky130_fd_sc_hd__decap_3
XFILLER_48_138 VGND VGND VPWR VPWR sky130_fd_sc_hd__fill_2
XPHY_EDGE_ROW_35_Right_35 VGND VGND VPWR VPWR sky130_fd_sc_hd__decap_3
XTAP_TAPCELL_ROW_14_203 VGND VPWR sky130_fd_sc_hd__tapvpwrvgnd_1
XFILLER_5_12 VGND VGND VPWR VPWR sky130_fd_sc_hd__fill_1
XFILLER_60_94 VGND VGND VPWR VPWR sky130_fd_sc_hd__fill_2
X_1470_ _2125_/Q hold277/X _1882_/S VGND VGND VPWR VPWR _2125_/D sky130_fd_sc_hd__mux2_1
XPHY_EDGE_ROW_44_Right_44 VGND VGND VPWR VPWR sky130_fd_sc_hd__decap_3
XFILLER_47_160 VGND VGND VPWR VPWR sky130_fd_sc_hd__fill_2
XPHY_EDGE_ROW_53_Right_53 VGND VGND VPWR VPWR sky130_fd_sc_hd__decap_3
XTAP_TAPCELL_ROW_37_317 VGND VPWR sky130_fd_sc_hd__tapvpwrvgnd_1
X_2022_ clkload3/A _2022_/D fanout66/X VGND VGND VPWR VPWR _2022_/Q sky130_fd_sc_hd__dfstp_2
X_1806_ _2041_/Q _1816_/A0 wire33/X VGND VGND VPWR VPWR _2041_/D sky130_fd_sc_hd__mux2_1
Xhold245 _2148_/Q VGND VGND VPWR VPWR _2149_/D sky130_fd_sc_hd__dlygate4sd3_1
Xhold256 _2140_/Q VGND VGND VPWR VPWR hold256/X sky130_fd_sc_hd__dlygate4sd3_1
Xhold267 _1907_/Q VGND VGND VPWR VPWR hold267/X sky130_fd_sc_hd__dlygate4sd3_1
Xhold289 _1913_/Q VGND VGND VPWR VPWR hold289/X sky130_fd_sc_hd__dlygate4sd3_1
Xhold278 _1921_/Q VGND VGND VPWR VPWR hold278/X sky130_fd_sc_hd__dlygate4sd3_1
X_1737_ _1994_/Q _1747_/B VGND VGND VPWR VPWR _1737_/Y sky130_fd_sc_hd__nor2_1
X_1668_ _1816_/A0 _1980_/Q _1668_/S VGND VGND VPWR VPWR _1965_/D sky130_fd_sc_hd__mux2_1
X_1599_ _1609_/A _1609_/B _1599_/C VGND VGND VPWR VPWR _1914_/D sky130_fd_sc_hd__nor3_1
XTAP_TAPCELL_ROW_51_386 VGND VPWR sky130_fd_sc_hd__tapvpwrvgnd_1
XFILLER_44_141 VGND VGND VPWR VPWR sky130_fd_sc_hd__fill_1
XTAP_TAPCELL_ROW_42_342 VGND VPWR sky130_fd_sc_hd__tapvpwrvgnd_1
X_0970_ _1812_/A _1721_/A _1721_/C _0971_/B VGND VGND VPWR VPWR _0973_/A sky130_fd_sc_hd__nand4b_1
X_1522_ _1897_/Q _1632_/B _1521_/Y VGND VGND VPWR VPWR _1523_/C sky130_fd_sc_hd__a21oi_1
X_1453_ _1624_/A _1624_/B _1942_/Q VGND VGND VPWR VPWR _1453_/X sky130_fd_sc_hd__or3_1
X_2005_ _2230_/CLK _2005_/D fanout66/X VGND VGND VPWR VPWR _2005_/Q sky130_fd_sc_hd__dfstp_2
X_1384_ _1444_/A3 _1382_/X _1383_/Y VGND VGND VPWR VPWR _1937_/D sky130_fd_sc_hd__a21oi_1
XTAP_TAPCELL_ROW_56_412 VGND VPWR sky130_fd_sc_hd__tapvpwrvgnd_1
XFILLER_49_222 VGND VGND VPWR VPWR sky130_fd_sc_hd__fill_2
X_0953_ _2217_/Q VGND VGND VPWR VPWR _0953_/Y sky130_fd_sc_hd__inv_1
X_1505_ _1610_/A _1346_/X _1504_/Y VGND VGND VPWR VPWR _1505_/Y sky130_fd_sc_hd__a21oi_1
X_1436_ _1615_/A _2082_/Q _0983_/B _1435_/X VGND VGND VPWR VPWR _1949_/D sky130_fd_sc_hd__o31a_1
X_1367_ _1943_/Q _1934_/Q VGND VGND VPWR VPWR _1370_/A sky130_fd_sc_hd__nand2_1
XFILLER_23_100 VGND VGND VPWR VPWR sky130_fd_sc_hd__fill_1
XFILLER_55_203 VGND VGND VPWR VPWR sky130_fd_sc_hd__fill_1
X_1298_ _2194_/Q _2229_/Q VGND VGND VPWR VPWR _1304_/B sky130_fd_sc_hd__xor2_1
XFILLER_23_133 VGND VGND VPWR VPWR sky130_fd_sc_hd__fill_2
XFILLER_23_199 VGND VGND VPWR VPWR sky130_fd_sc_hd__decap_4
XFILLER_14_166 VGND VGND VPWR VPWR sky130_fd_sc_hd__fill_2
XFILLER_36_85 VGND VGND VPWR VPWR sky130_fd_sc_hd__decap_4
X_1221_ _2014_/Q _1300_/B1 _1220_/X VGND VGND VPWR VPWR _2207_/D sky130_fd_sc_hd__o21a_1
X_1152_ _2023_/Q _1329_/A2 _1150_/Y _1151_/Y VGND VGND VPWR VPWR _2216_/D sky130_fd_sc_hd__o2bb2ai_1
X_1083_ _1459_/B _1604_/B _2041_/Q VGND VGND VPWR VPWR _1083_/Y sky130_fd_sc_hd__o21ai_0
X_1985_ clkload9/A _1985_/D fanout73/X VGND VGND VPWR VPWR _1985_/Q sky130_fd_sc_hd__dfrtp_1
XFILLER_28_225 VGND VGND VPWR VPWR sky130_fd_sc_hd__fill_1
X_1419_ _2092_/Q _1456_/A2 _1456_/B1 _2076_/Q VGND VGND VPWR VPWR _1419_/Y sky130_fd_sc_hd__o22ai_1
XFILLER_11_169 VGND VGND VPWR VPWR sky130_fd_sc_hd__decap_3
XFILLER_19_269 VGND VGND VPWR VPWR sky130_fd_sc_hd__fill_1
XTAP_TAPCELL_ROW_29_275 VGND VPWR sky130_fd_sc_hd__tapvpwrvgnd_1
XTAP_TAPCELL_ROW_6_162 VGND VPWR sky130_fd_sc_hd__tapvpwrvgnd_1
Xfanout160 _2144_/Q VGND VGND VPWR VPWR _1664_/B sky130_fd_sc_hd__clkdlybuf4s50_1
Xfanout171 _2138_/Q VGND VGND VPWR VPWR _1458_/A1 sky130_fd_sc_hd__clkdlybuf4s50_1
Xfanout182 _1966_/Q VGND VGND VPWR VPWR _1817_/A0 sky130_fd_sc_hd__clkdlybuf4s50_1
Xfanout193 _1422_/S VGND VGND VPWR VPWR _1392_/S sky130_fd_sc_hd__clkdlybuf4s50_1
XFILLER_42_283 VGND VGND VPWR VPWR sky130_fd_sc_hd__fill_2
X_1770_ _1818_/A0 _2011_/Q wire38/X VGND VGND VPWR VPWR _2011_/D sky130_fd_sc_hd__mux2_1
XFILLER_6_195 VGND VGND VPWR VPWR sky130_fd_sc_hd__fill_1
XFILLER_33_3 VGND VGND VPWR VPWR sky130_fd_sc_hd__decap_3
X_2184_ _2223_/CLK _2184_/D VGND VGND VPWR VPWR _2184_/Q sky130_fd_sc_hd__dfxtp_1
Xclkbuf_leaf_2_dclk clkbuf_leaf_2_dclk/A VGND VGND VPWR VPWR clkload2/A sky130_fd_sc_hd__clkbuf_16
X_1204_ _1207_/A _2218_/Q VGND VGND VPWR VPWR _1204_/Y sky130_fd_sc_hd__nor2b_1
X_1135_ _2196_/Q _1135_/B _1140_/B VGND VGND VPWR VPWR _1135_/X sky130_fd_sc_hd__xnor3_1
X_1066_ _2183_/Q _1143_/B _1075_/B VGND VGND VPWR VPWR _1066_/X sky130_fd_sc_hd__xor3_1
X_1968_ _2166_/CLK _1968_/D load_slew79/X VGND VGND VPWR VPWR _1968_/Q sky130_fd_sc_hd__dfrtp_1
X_1899_ clkload8/A _1899_/D VGND VGND VPWR VPWR _1899_/Q sky130_fd_sc_hd__dfxtp_1
XFILLER_58_94 VGND VGND VPWR VPWR sky130_fd_sc_hd__fill_1
X_1822_ _1812_/A _2054_/Q _1829_/S VGND VGND VPWR VPWR _2054_/D sky130_fd_sc_hd__mux2_1
X_1753_ _2133_/Q _2132_/Q VGND VGND VPWR VPWR _1858_/D sky130_fd_sc_hd__nor2_1
X_1684_ _1973_/Q _1994_/Q _1686_/S VGND VGND VPWR VPWR _1684_/Y sky130_fd_sc_hd__mux2i_1
XTAP_TAPCELL_ROW_0_124 VGND VPWR sky130_fd_sc_hd__tapvpwrvgnd_1
XTAP_TAPCELL_ROW_48_370 VGND VPWR sky130_fd_sc_hd__tapvpwrvgnd_1
X_2167_ clkload3/A _2167_/D VGND VGND VPWR VPWR _2167_/Q sky130_fd_sc_hd__dfxtp_1
XTAP_TAPCELL_ROW_23_248 VGND VPWR sky130_fd_sc_hd__tapvpwrvgnd_1
X_2098_ clkload7/A _2098_/D _2145_/SET_B VGND VGND VPWR VPWR _2098_/Q sky130_fd_sc_hd__dfrtp_1
X_1118_ _1459_/B _1664_/B _2000_/Q VGND VGND VPWR VPWR _1118_/Y sky130_fd_sc_hd__o21ai_0
X_1049_ _1054_/A _1049_/B _1055_/A _1049_/D VGND VGND VPWR VPWR _1050_/B sky130_fd_sc_hd__nand4_1
XFILLER_48_117 VGND VGND VPWR VPWR sky130_fd_sc_hd__fill_2
XFILLER_12_264 VGND VGND VPWR VPWR sky130_fd_sc_hd__fill_2
XFILLER_8_279 VGND VGND VPWR VPWR sky130_fd_sc_hd__decap_6
XTAP_TAPCELL_ROW_37_318 VGND VPWR sky130_fd_sc_hd__tapvpwrvgnd_1
X_2021_ _2230_/CLK _2021_/D wire86/X VGND VGND VPWR VPWR _2021_/Q sky130_fd_sc_hd__dfrtp_1
XPHY_EDGE_ROW_17_Left_79 VGND VGND VPWR VPWR sky130_fd_sc_hd__decap_3
XTAP_TAPCELL_ROW_20_229 VGND VPWR sky130_fd_sc_hd__tapvpwrvgnd_1
X_1805_ _2040_/Q _1824_/A0 _1805_/S VGND VGND VPWR VPWR _2040_/D sky130_fd_sc_hd__mux2_1
X_1736_ _1747_/B _1734_/Y _1735_/Y _1733_/Y VGND VGND VPWR VPWR _1993_/D sky130_fd_sc_hd__a31oi_1
Xhold246 _2150_/Q VGND VGND VPWR VPWR _2151_/D sky130_fd_sc_hd__dlygate4sd3_1
Xhold257 _2024_/Q VGND VGND VPWR VPWR hold257/X sky130_fd_sc_hd__dlygate4sd3_1
Xhold268 _2049_/Q VGND VGND VPWR VPWR hold268/X sky130_fd_sc_hd__dlygate4sd3_1
Xhold279 _1891_/Q VGND VGND VPWR VPWR hold279/X sky130_fd_sc_hd__dlygate4sd3_1
X_1667_ _1721_/A _1979_/Q _1668_/S VGND VGND VPWR VPWR _1964_/D sky130_fd_sc_hd__mux2_1
X_1598_ _1914_/Q _1607_/B _1597_/Y VGND VGND VPWR VPWR _1599_/C sky130_fd_sc_hd__a21oi_1
X_2219_ _2219_/CLK _2219_/D VGND VGND VPWR VPWR _2219_/Q sky130_fd_sc_hd__dfxtp_1
XTAP_TAPCELL_ROW_51_387 VGND VPWR sky130_fd_sc_hd__tapvpwrvgnd_1
XFILLER_39_96 VGND VGND VPWR VPWR sky130_fd_sc_hd__fill_2
XFILLER_44_186 VGND VGND VPWR VPWR sky130_fd_sc_hd__fill_1
XFILLER_44_197 VGND VGND VPWR VPWR sky130_fd_sc_hd__decap_3
XTAP_TAPCELL_ROW_42_343 VGND VPWR sky130_fd_sc_hd__tapvpwrvgnd_1
X_1521_ _1630_/A _1370_/X _1520_/Y VGND VGND VPWR VPWR _1521_/Y sky130_fd_sc_hd__a21oi_1
X_1452_ _1452_/A1 _2090_/Q _0983_/B _1451_/X VGND VGND VPWR VPWR _1957_/D sky130_fd_sc_hd__o31a_1
X_1383_ _2086_/Q _1448_/A2 _1448_/B1 _2070_/Q VGND VGND VPWR VPWR _1383_/Y sky130_fd_sc_hd__o22ai_1
X_2004_ _2230_/CLK _2004_/D fanout66/X VGND VGND VPWR VPWR _2004_/Q sky130_fd_sc_hd__dfrtp_1
XFILLER_50_167 VGND VGND VPWR VPWR sky130_fd_sc_hd__fill_2
X_1719_ _1719_/A _1719_/B _0969_/Y VGND VGND VPWR VPWR wire42/A sky130_fd_sc_hd__nor3b_2
XTAP_TAPCELL_ROW_56_413 VGND VPWR sky130_fd_sc_hd__tapvpwrvgnd_1
XFILLER_26_186 VGND VGND VPWR VPWR sky130_fd_sc_hd__fill_2
XFILLER_41_53 VGND VGND VPWR VPWR sky130_fd_sc_hd__decap_3
XFILLER_1_252 VGND VGND VPWR VPWR sky130_fd_sc_hd__fill_1
XFILLER_1_274 VGND VGND VPWR VPWR sky130_fd_sc_hd__decap_6
XFILLER_17_197 VGND VGND VPWR VPWR sky130_fd_sc_hd__fill_1
XFILLER_32_101 VGND VGND VPWR VPWR sky130_fd_sc_hd__fill_2
X_0952_ _2038_/Q VGND VGND VPWR VPWR _0952_/Y sky130_fd_sc_hd__inv_1
X_1504_ _1610_/A _1931_/Q _1556_/B1 VGND VGND VPWR VPWR _1504_/Y sky130_fd_sc_hd__o21ai_0
X_1435_ _1634_/A _1634_/B _1933_/Q _2066_/Q _1451_/B2 VGND VGND VPWR VPWR _1435_/X
+ sky130_fd_sc_hd__o32a_1
X_1366_ _1495_/B1 _1364_/X _1365_/Y VGND VGND VPWR VPWR _1934_/D sky130_fd_sc_hd__a21oi_1
XPHY_EDGE_ROW_43_Left_105 VGND VGND VPWR VPWR sky130_fd_sc_hd__decap_3
X_1297_ _2055_/Q _1297_/A2 _1296_/Y VGND VGND VPWR VPWR _2192_/D sky130_fd_sc_hd__a21o_1
XPHY_EDGE_ROW_52_Left_114 VGND VGND VPWR VPWR sky130_fd_sc_hd__decap_3
XPHY_EDGE_ROW_61_Left_123 VGND VGND VPWR VPWR sky130_fd_sc_hd__decap_3
X_1220_ _1380_/S _2191_/Q _1219_/Y _1297_/A2 VGND VGND VPWR VPWR _1220_/X sky130_fd_sc_hd__a211o_1
X_1151_ _1344_/S _2168_/Q _1300_/B1 VGND VGND VPWR VPWR _1151_/Y sky130_fd_sc_hd__o21ai_0
X_1082_ _1329_/A2 _1081_/X _1078_/Y VGND VGND VPWR VPWR _2169_/D sky130_fd_sc_hd__o21ai_0
X_1984_ _2166_/CLK _1984_/D load_slew79/X VGND VGND VPWR VPWR _1984_/Q sky130_fd_sc_hd__dfrtp_1
X_1418_ _1418_/A _1418_/B _1418_/C VGND VGND VPWR VPWR _1418_/X sky130_fd_sc_hd__xnor3_1
X_1349_ _1931_/Q _1940_/Q VGND VGND VPWR VPWR _1352_/A sky130_fd_sc_hd__nand2_1
Xwire96 wire96/A VGND VGND VPWR VPWR wire96/X sky130_fd_sc_hd__clkbuf_2
Xwire52 wire52/A VGND VGND VPWR VPWR wire52/X sky130_fd_sc_hd__clkdlybuf4s25_1
XPHY_EDGE_ROW_5_Left_67 VGND VGND VPWR VPWR sky130_fd_sc_hd__decap_3
XTAP_TAPCELL_ROW_6_163 VGND VPWR sky130_fd_sc_hd__tapvpwrvgnd_1
Xfanout150 fanout151/X VGND VGND VPWR VPWR _1604_/A sky130_fd_sc_hd__clkdlybuf4s50_1
Xfanout161 _1620_/A VGND VGND VPWR VPWR _1615_/A sky130_fd_sc_hd__clkdlybuf4s50_1
Xfanout172 _2128_/Q VGND VGND VPWR VPWR _1774_/D sky130_fd_sc_hd__clkdlybuf4s50_1
Xfanout183 _1965_/Q VGND VGND VPWR VPWR _0972_/A sky130_fd_sc_hd__clkdlybuf4s50_1
XFILLER_27_281 VGND VGND VPWR VPWR sky130_fd_sc_hd__decap_4
XTAP_TAPCELL_ROW_29_276 VGND VPWR sky130_fd_sc_hd__tapvpwrvgnd_1
Xfanout194 _1422_/S VGND VGND VPWR VPWR _1416_/S sky130_fd_sc_hd__clkdlybuf4s50_1
XFILLER_6_141 VGND VGND VPWR VPWR sky130_fd_sc_hd__fill_2
XFILLER_26_3 VGND VGND VPWR VPWR sky130_fd_sc_hd__decap_3
X_2183_ clkload3/A _2183_/D VGND VGND VPWR VPWR _2183_/Q sky130_fd_sc_hd__dfxtp_1
X_1203_ _2008_/Q _1300_/B1 _1202_/Y VGND VGND VPWR VPWR _2201_/D sky130_fd_sc_hd__o21a_1
X_1134_ _2213_/Q _2168_/Q VGND VGND VPWR VPWR _1140_/B sky130_fd_sc_hd__xor2_1
X_1065_ _2200_/Q _2171_/Q VGND VGND VPWR VPWR _1075_/B sky130_fd_sc_hd__xor2_1
X_1967_ _2166_/CLK _1967_/D load_slew79/X VGND VGND VPWR VPWR _1967_/Q sky130_fd_sc_hd__dfrtp_1
X_1898_ clkload9/A _1898_/D VGND VGND VPWR VPWR _1898_/Q sky130_fd_sc_hd__dfxtp_1
XTAP_TAPCELL_ROW_3_144 VGND VPWR sky130_fd_sc_hd__tapvpwrvgnd_1
XFILLER_24_251 VGND VGND VPWR VPWR sky130_fd_sc_hd__fill_1
XFILLER_15_251 VGND VGND VPWR VPWR sky130_fd_sc_hd__decap_12
X_1821_ _1858_/A wire94/A _1821_/C VGND VGND VPWR VPWR _1829_/S sky130_fd_sc_hd__nand3_1
X_1752_ _1749_/B _1750_/Y _1751_/Y _1749_/Y VGND VGND VPWR VPWR _1997_/D sky130_fd_sc_hd__a31oi_1
X_1683_ _1973_/Q _1673_/X _1687_/B1 _1682_/Y VGND VGND VPWR VPWR _1973_/D sky130_fd_sc_hd__a2bb2oi_1
XTAP_TAPCELL_ROW_0_125 VGND VPWR sky130_fd_sc_hd__tapvpwrvgnd_1
XTAP_TAPCELL_ROW_48_371 VGND VPWR sky130_fd_sc_hd__tapvpwrvgnd_1
X_2166_ _2166_/CLK _2166_/D fanout87/X VGND VGND VPWR VPWR _2166_/Q sky130_fd_sc_hd__dfrtp_1
X_2097_ clkload0/A _2097_/D fanout56/X VGND VGND VPWR VPWR _2097_/Q sky130_fd_sc_hd__dfrtp_1
X_1117_ _1282_/A2 _1116_/Y _1113_/Y VGND VGND VPWR VPWR _2176_/D sky130_fd_sc_hd__o21ai_0
XFILLER_21_254 VGND VGND VPWR VPWR sky130_fd_sc_hd__decap_4
XPHY_EDGE_ROW_3_Right_3 VGND VGND VPWR VPWR sky130_fd_sc_hd__decap_3
X_1048_ _1055_/C _1923_/Q _1048_/C VGND VGND VPWR VPWR _1049_/D sky130_fd_sc_hd__nand3_1
XFILLER_0_169 VGND VGND VPWR VPWR sky130_fd_sc_hd__fill_1
XFILLER_12_243 VGND VGND VPWR VPWR sky130_fd_sc_hd__decap_4
XPHY_EDGE_ROW_8_Left_70 VGND VGND VPWR VPWR sky130_fd_sc_hd__decap_3
X_2020_ clkload5/A _2020_/D fanout64/X VGND VGND VPWR VPWR _2020_/Q sky130_fd_sc_hd__dfrtp_1
Xhold247 _2159_/Q VGND VGND VPWR VPWR _2160_/D sky130_fd_sc_hd__dlygate4sd3_1
Xhold258 _2029_/Q VGND VGND VPWR VPWR hold258/X sky130_fd_sc_hd__dlygate4sd3_1
Xhold269 _1893_/Q VGND VGND VPWR VPWR hold269/X sky130_fd_sc_hd__dlygate4sd3_1
X_1804_ _2039_/Q _1718_/D _1805_/S VGND VGND VPWR VPWR _2039_/D sky130_fd_sc_hd__mux2_1
X_1735_ _2121_/Q _1746_/A2 wire93/X _2113_/Q _2105_/Q wire97/X VGND VGND VPWR VPWR
+ _1735_/Y sky130_fd_sc_hd__a222oi_1
X_1666_ _0968_/A _1978_/Q _1668_/S VGND VGND VPWR VPWR _1963_/D sky130_fd_sc_hd__mux2_1
X_1597_ _1597_/A _1607_/B _1597_/C VGND VGND VPWR VPWR _1597_/Y sky130_fd_sc_hd__nor3_1
XFILLER_38_195 VGND VGND VPWR VPWR sky130_fd_sc_hd__fill_1
XFILLER_53_110 VGND VGND VPWR VPWR sky130_fd_sc_hd__fill_2
X_2218_ _2219_/CLK _2218_/D VGND VGND VPWR VPWR _2218_/Q sky130_fd_sc_hd__dfxtp_1
X_2149_ _2221_/CLK _2149_/D input1/X VGND VGND VPWR VPWR _2149_/Q sky130_fd_sc_hd__dfrtp_1
XTAP_TAPCELL_ROW_51_388 VGND VPWR sky130_fd_sc_hd__tapvpwrvgnd_1
XPHY_EDGE_ROW_34_Left_96 VGND VGND VPWR VPWR sky130_fd_sc_hd__decap_3
XFILLER_44_165 VGND VGND VPWR VPWR sky130_fd_sc_hd__fill_1
X_1520_ _1630_/A _1935_/Q _1552_/B1 VGND VGND VPWR VPWR _1520_/Y sky130_fd_sc_hd__o21ai_0
X_1451_ _1624_/A _1624_/B _1941_/Q _2074_/Q _1451_/B2 VGND VGND VPWR VPWR _1451_/X
+ sky130_fd_sc_hd__o32a_1
X_1382_ _1382_/A _1382_/B _1382_/C VGND VGND VPWR VPWR _1382_/X sky130_fd_sc_hd__xnor3_1
XFILLER_50_102 VGND VGND VPWR VPWR sky130_fd_sc_hd__fill_1
X_2003_ clkload3/A _2003_/D wire68/X VGND VGND VPWR VPWR _2003_/Q sky130_fd_sc_hd__dfstp_2
X_1718_ _1816_/A0 _1721_/A _1721_/D _1718_/D VGND VGND VPWR VPWR _1719_/A sky130_fd_sc_hd__nand4b_1
X_1649_ _0965_/C _0980_/Y _1645_/Y VGND VGND VPWR VPWR _1649_/Y sky130_fd_sc_hd__o21ai_0
XFILLER_26_165 VGND VGND VPWR VPWR sky130_fd_sc_hd__fill_1
XFILLER_1_242 VGND VGND VPWR VPWR sky130_fd_sc_hd__fill_1
X_0951_ _1988_/Q VGND VGND VPWR VPWR _0996_/D sky130_fd_sc_hd__inv_1
X_1503_ _1609_/A _1609_/B _1503_/C VGND VGND VPWR VPWR _1892_/D sky130_fd_sc_hd__nor3_1
X_1434_ _1630_/A _2081_/Q _0983_/B _1433_/X VGND VGND VPWR VPWR _1948_/D sky130_fd_sc_hd__o31a_1
X_1365_ _2083_/Q _1451_/B2 _1456_/B1 _2067_/Q VGND VGND VPWR VPWR _1365_/Y sky130_fd_sc_hd__o22ai_1
X_1296_ _1386_/S _1294_/X _1295_/Y VGND VGND VPWR VPWR _1296_/Y sky130_fd_sc_hd__a21oi_1
XFILLER_14_135 VGND VGND VPWR VPWR sky130_fd_sc_hd__decap_4
XFILLER_36_98 VGND VGND VPWR VPWR sky130_fd_sc_hd__fill_2
X_1150_ _2200_/Q _1344_/S VGND VGND VPWR VPWR _1150_/Y sky130_fd_sc_hd__nor2b_1
X_1081_ _1080_/X _0953_/Y _1344_/S VGND VGND VPWR VPWR _1081_/X sky130_fd_sc_hd__mux2_1
XFILLER_20_149 VGND VGND VPWR VPWR sky130_fd_sc_hd__fill_1
XFILLER_9_161 VGND VGND VPWR VPWR sky130_fd_sc_hd__decap_6
XPHY_EDGE_ROW_21_Left_83 VGND VGND VPWR VPWR sky130_fd_sc_hd__decap_3
X_1983_ _2166_/CLK _1983_/D load_slew79/X VGND VGND VPWR VPWR _1983_/Q sky130_fd_sc_hd__dfrtp_1
X_1417_ _1941_/Q _1959_/Q VGND VGND VPWR VPWR _1418_/C sky130_fd_sc_hd__xor2_1
Xwire42 wire42/A VGND VGND VPWR VPWR wire42/X sky130_fd_sc_hd__clkbuf_2
Xwire31 wire31/A VGND VGND VPWR VPWR wire31/X sky130_fd_sc_hd__buf_2
X_1348_ _1450_/A3 _1346_/X _1347_/Y VGND VGND VPWR VPWR _1931_/D sky130_fd_sc_hd__a21oi_1
X_1279_ _2173_/Q _1279_/B _1284_/B VGND VGND VPWR VPWR _1279_/X sky130_fd_sc_hd__xor3_1
Xwire97 wire98/X VGND VGND VPWR VPWR wire97/X sky130_fd_sc_hd__clkbuf_2
Xwire86 wire86/A VGND VGND VPWR VPWR wire86/X sky130_fd_sc_hd__clkbuf_4
Xwire75 wire75/A VGND VGND VPWR VPWR wire75/X sky130_fd_sc_hd__clkbuf_4
Xfanout140 _1327_/B1 VGND VGND VPWR VPWR _1270_/B1 sky130_fd_sc_hd__clkdlybuf4s50_1
Xfanout151 _2145_/Q VGND VGND VPWR VPWR fanout151/X sky130_fd_sc_hd__clkdlybuf4s50_1
Xfanout162 _1452_/A1 VGND VGND VPWR VPWR _1620_/A sky130_fd_sc_hd__clkdlybuf4s50_1
Xfanout173 _2127_/Q VGND VGND VPWR VPWR _1840_/B sky130_fd_sc_hd__clkdlybuf4s50_1
Xfanout184 _1965_/Q VGND VGND VPWR VPWR _1816_/A0 sky130_fd_sc_hd__clkdlybuf4s50_1
Xfanout195 _1422_/S VGND VGND VPWR VPWR _1248_/B sky130_fd_sc_hd__clkdlybuf4s50_1
XTAP_TAPCELL_ROW_29_277 VGND VPWR sky130_fd_sc_hd__tapvpwrvgnd_1
XFILLER_19_3 VGND VGND VPWR VPWR sky130_fd_sc_hd__fill_2
X_2182_ _2230_/CLK _2182_/D VGND VGND VPWR VPWR _2182_/Q sky130_fd_sc_hd__dfxtp_1
X_1202_ _1362_/S _0953_/Y _1300_/B1 _1201_/Y VGND VGND VPWR VPWR _1202_/Y sky130_fd_sc_hd__o211ai_1
X_1133_ _1629_/A _1629_/B _2003_/Q VGND VGND VPWR VPWR _1133_/Y sky130_fd_sc_hd__o21ai_0
X_1064_ _2199_/Q _2170_/Q VGND VGND VPWR VPWR _1143_/B sky130_fd_sc_hd__xor2_1
XFILLER_18_282 VGND VGND VPWR VPWR sky130_fd_sc_hd__decap_3
X_1966_ _2166_/CLK _1966_/D load_slew79/X VGND VGND VPWR VPWR _1966_/Q sky130_fd_sc_hd__dfrtp_1
X_1897_ clkload0/A _1897_/D VGND VGND VPWR VPWR _1897_/Q sky130_fd_sc_hd__dfxtp_1
XFILLER_17_45 VGND VGND VPWR VPWR sky130_fd_sc_hd__fill_2
XFILLER_17_89 VGND VGND VPWR VPWR sky130_fd_sc_hd__decap_3
XTAP_TAPCELL_ROW_3_145 VGND VPWR sky130_fd_sc_hd__tapvpwrvgnd_1
XFILLER_15_263 VGND VGND VPWR VPWR sky130_fd_sc_hd__decap_8
XTAP_TAPCELL_ROW_17_214 VGND VPWR sky130_fd_sc_hd__tapvpwrvgnd_1
X_1820_ _1820_/A0 _2053_/Q wire31/X VGND VGND VPWR VPWR _2053_/D sky130_fd_sc_hd__mux2_1
Xmax_cap115 _1021_/C VGND VGND VPWR VPWR _1024_/A2 sky130_fd_sc_hd__clkdlybuf4s25_1
X_1751_ _2117_/Q wire94/X wire42/X _2101_/Q VGND VGND VPWR VPWR _1751_/Y sky130_fd_sc_hd__a22oi_1
X_1682_ _1972_/Q _1993_/Q _1682_/S VGND VGND VPWR VPWR _1682_/Y sky130_fd_sc_hd__mux2i_1
XFILLER_0_81 VGND VGND VPWR VPWR sky130_fd_sc_hd__decap_3
XTAP_TAPCELL_ROW_0_126 VGND VPWR sky130_fd_sc_hd__tapvpwrvgnd_1
XTAP_TAPCELL_ROW_48_372 VGND VPWR sky130_fd_sc_hd__tapvpwrvgnd_1
X_2165_ _2224_/CLK _2165_/D fanout87/X VGND VGND VPWR VPWR _2165_/Q sky130_fd_sc_hd__dfrtp_1
X_2096_ clkload1/A _2096_/D fanout59/A VGND VGND VPWR VPWR _2096_/Q sky130_fd_sc_hd__dfrtp_1
X_1116_ _1115_/X _2224_/Q _1374_/S VGND VGND VPWR VPWR _1116_/Y sky130_fd_sc_hd__mux2i_1
X_1047_ _1054_/A _1047_/B _1047_/C VGND VGND VPWR VPWR _1050_/A sky130_fd_sc_hd__nand3b_1
XFILLER_21_211 VGND VGND VPWR VPWR sky130_fd_sc_hd__decap_4
X_1949_ clkload7/A _1949_/D _1950_/DE VGND VGND VPWR VPWR _1949_/Q sky130_fd_sc_hd__edfxtp_1
XFILLER_0_137 VGND VGND VPWR VPWR sky130_fd_sc_hd__decap_3
XFILLER_56_152 VGND VGND VPWR VPWR sky130_fd_sc_hd__decap_6
XFILLER_8_259 VGND VGND VPWR VPWR sky130_fd_sc_hd__fill_1
XFILLER_47_141 VGND VGND VPWR VPWR sky130_fd_sc_hd__fill_2
XPHY_EDGE_ROW_13_Right_13 VGND VGND VPWR VPWR sky130_fd_sc_hd__decap_3
XPHY_EDGE_ROW_22_Right_22 VGND VGND VPWR VPWR sky130_fd_sc_hd__decap_3
X_1803_ _0952_/Y _1805_/S _1802_/Y VGND VGND VPWR VPWR _2038_/D sky130_fd_sc_hd__o21ai_0
XFILLER_7_270 VGND VGND VPWR VPWR sky130_fd_sc_hd__fill_1
XFILLER_7_281 VGND VGND VPWR VPWR sky130_fd_sc_hd__decap_4
Xhold248 _2161_/Q VGND VGND VPWR VPWR _2162_/D sky130_fd_sc_hd__dlygate4sd3_1
Xhold259 _2026_/Q VGND VGND VPWR VPWR hold259/X sky130_fd_sc_hd__dlygate4sd3_1
X_1734_ _2097_/Q _1745_/B VGND VGND VPWR VPWR _1734_/Y sky130_fd_sc_hd__nand2_1
X_1665_ _1719_/B _1989_/Q _1669_/S VGND VGND VPWR VPWR _1962_/D sky130_fd_sc_hd__mux2_1
X_1596_ _1936_/Q _1605_/A VGND VGND VPWR VPWR _1597_/A sky130_fd_sc_hd__nor2b_1
XPHY_EDGE_ROW_31_Right_31 VGND VGND VPWR VPWR sky130_fd_sc_hd__decap_3
X_2217_ _2223_/CLK _2217_/D VGND VGND VPWR VPWR _2217_/Q sky130_fd_sc_hd__dfxtp_1
X_2148_ _2221_/CLK _2148_/D input1/X VGND VGND VPWR VPWR _2148_/Q sky130_fd_sc_hd__dfrtp_1
X_2079_ clkload8/A _2079_/D load_slew70/X VGND VGND VPWR VPWR _2079_/Q sky130_fd_sc_hd__dfrtp_1
XPHY_EDGE_ROW_40_Right_40 VGND VGND VPWR VPWR sky130_fd_sc_hd__decap_3
X_1450_ _1630_/A _2089_/Q _1450_/A3 _1449_/X VGND VGND VPWR VPWR _1956_/D sky130_fd_sc_hd__o31a_1
X_1381_ _1935_/Q _1953_/Q VGND VGND VPWR VPWR _1382_/C sky130_fd_sc_hd__xor2_1
XFILLER_35_111 VGND VGND VPWR VPWR sky130_fd_sc_hd__fill_1
X_2002_ clkload4/A _2002_/D wire68/X VGND VGND VPWR VPWR _2002_/Q sky130_fd_sc_hd__dfrtp_1
X_1717_ _1840_/A _1774_/D _2129_/Q _1840_/B VGND VGND VPWR VPWR wire94/A sky130_fd_sc_hd__nor4b_2
X_1648_ fanout8/X _1646_/Y _1647_/Y VGND VGND VPWR VPWR _1924_/D sky130_fd_sc_hd__a21oi_1
X_1579_ _1634_/A _1634_/B _1579_/C VGND VGND VPWR VPWR _1910_/D sky130_fd_sc_hd__nor3_1
XFILLER_41_77 VGND VGND VPWR VPWR sky130_fd_sc_hd__fill_2
XFILLER_1_265 VGND VGND VPWR VPWR sky130_fd_sc_hd__fill_1
XFILLER_32_136 VGND VGND VPWR VPWR sky130_fd_sc_hd__decap_4
X_0950_ _1652_/C VGND VGND VPWR VPWR _1045_/C sky130_fd_sc_hd__inv_1
Xclkbuf_leaf_5_dclk clkbuf_leaf_9_dclk/A VGND VGND VPWR VPWR _2161_/CLK sky130_fd_sc_hd__clkbuf_16
X_1502_ _1892_/Q _1607_/B _1501_/Y VGND VGND VPWR VPWR _1503_/C sky130_fd_sc_hd__a21oi_1
X_1433_ _1624_/A _1624_/B _1932_/Q _2065_/Q _1451_/B2 VGND VGND VPWR VPWR _1433_/X
+ sky130_fd_sc_hd__o32a_1
X_1364_ _1364_/A _1364_/B _1364_/C VGND VGND VPWR VPWR _1364_/X sky130_fd_sc_hd__xnor3_1
X_1295_ _1386_/S _2208_/Q _1300_/B1 VGND VGND VPWR VPWR _1295_/Y sky130_fd_sc_hd__o21ai_0
XTAP_TAPCELL_ROW_61_440 VGND VPWR sky130_fd_sc_hd__tapvpwrvgnd_1
X_1080_ _2185_/Q _1080_/B _1085_/B VGND VGND VPWR VPWR _1080_/X sky130_fd_sc_hd__xnor3_1
XFILLER_60_253 VGND VGND VPWR VPWR sky130_fd_sc_hd__fill_1
X_1982_ _2166_/CLK _1982_/D load_slew79/X VGND VGND VPWR VPWR _1982_/Q sky130_fd_sc_hd__dfrtp_1
X_1416_ _2197_/Q _2181_/Q _1416_/S VGND VGND VPWR VPWR _1418_/B sky130_fd_sc_hd__mux2i_1
X_1347_ _2080_/Q _1448_/A2 _1448_/B1 _2064_/Q VGND VGND VPWR VPWR _1347_/Y sky130_fd_sc_hd__o22ai_1
XFILLER_36_250 VGND VGND VPWR VPWR sky130_fd_sc_hd__fill_2
XFILLER_36_283 VGND VGND VPWR VPWR sky130_fd_sc_hd__fill_2
X_1278_ _2190_/Q _2225_/Q VGND VGND VPWR VPWR _1284_/B sky130_fd_sc_hd__xor2_1
Xwire98 wire98/A VGND VGND VPWR VPWR wire98/X sky130_fd_sc_hd__clkbuf_2
XFILLER_47_54 VGND VGND VPWR VPWR sky130_fd_sc_hd__fill_2
Xfanout130 _1495_/B1 VGND VGND VPWR VPWR _0983_/B sky130_fd_sc_hd__clkdlybuf4s50_1
Xfanout141 _0955_/Y VGND VGND VPWR VPWR _1327_/B1 sky130_fd_sc_hd__clkdlybuf4s50_1
Xfanout163 _1452_/A1 VGND VGND VPWR VPWR _1630_/A sky130_fd_sc_hd__clkdlybuf4s50_1
Xfanout174 _2126_/Q VGND VGND VPWR VPWR _1840_/A sky130_fd_sc_hd__clkdlybuf4s50_1
Xfanout185 _1964_/Q VGND VGND VPWR VPWR _1721_/A sky130_fd_sc_hd__clkdlybuf4s50_1
Xfanout196 _1422_/S VGND VGND VPWR VPWR _1331_/S sky130_fd_sc_hd__clkdlybuf4s50_1
XTAP_TAPCELL_ROW_29_278 VGND VPWR sky130_fd_sc_hd__tapvpwrvgnd_1
XFILLER_10_194 VGND VGND VPWR VPWR sky130_fd_sc_hd__fill_2
XFILLER_6_165 VGND VGND VPWR VPWR sky130_fd_sc_hd__fill_1
XTAP_TAPCELL_ROW_12_189 VGND VPWR sky130_fd_sc_hd__tapvpwrvgnd_1
X_1201_ _1362_/S _2185_/Q VGND VGND VPWR VPWR _1201_/Y sky130_fd_sc_hd__nand2_1
X_2181_ _2230_/CLK _2181_/D VGND VGND VPWR VPWR _2181_/Q sky130_fd_sc_hd__dfxtp_1
X_1132_ _1661_/B1 _1131_/Y _1128_/Y VGND VGND VPWR VPWR _2179_/D sky130_fd_sc_hd__o21ai_0
X_1063_ _1062_/B _1062_/A _1051_/Y _1052_/A VGND VGND VPWR VPWR _1063_/Y sky130_fd_sc_hd__a22oi_1
X_1965_ _2161_/CLK _1965_/D wire75/X VGND VGND VPWR VPWR _1965_/Q sky130_fd_sc_hd__dfrtp_1
X_1896_ clkload6/A _1896_/D VGND VGND VPWR VPWR _1896_/Q sky130_fd_sc_hd__dfxtp_1
XTAP_TAPCELL_ROW_3_146 VGND VPWR sky130_fd_sc_hd__tapvpwrvgnd_1
XFILLER_17_35 VGND VGND VPWR VPWR sky130_fd_sc_hd__fill_2
XFILLER_24_231 VGND VGND VPWR VPWR sky130_fd_sc_hd__decap_8
XTAP_TAPCELL_ROW_26_259 VGND VPWR sky130_fd_sc_hd__tapvpwrvgnd_1
XPHY_EDGE_ROW_49_Left_111 VGND VGND VPWR VPWR sky130_fd_sc_hd__decap_3
XPHY_EDGE_ROW_58_Left_120 VGND VGND VPWR VPWR sky130_fd_sc_hd__decap_3
XTAP_TAPCELL_ROW_17_215 VGND VPWR sky130_fd_sc_hd__tapvpwrvgnd_1
X_1750_ _2109_/Q wire98/X wire96/X _2125_/Q VGND VGND VPWR VPWR _1750_/Y sky130_fd_sc_hd__a22oi_1
X_1681_ _1972_/Q _1673_/X _1687_/B1 _1680_/Y VGND VGND VPWR VPWR _1972_/D sky130_fd_sc_hd__a2bb2oi_1
XFILLER_31_3 VGND VGND VPWR VPWR sky130_fd_sc_hd__decap_3
X_2164_ _2221_/CLK input3/X fanout88/X VGND VGND VPWR VPWR _2164_/Q sky130_fd_sc_hd__dfrtp_1
XFILLER_0_71 VGND VGND VPWR VPWR sky130_fd_sc_hd__fill_2
XTAP_TAPCELL_ROW_0_127 VGND VPWR sky130_fd_sc_hd__tapvpwrvgnd_1
XTAP_TAPCELL_ROW_48_373 VGND VPWR sky130_fd_sc_hd__tapvpwrvgnd_1
X_2095_ clkload8/A _2095_/D load_slew70/X VGND VGND VPWR VPWR _2095_/Q sky130_fd_sc_hd__dfrtp_1
X_1115_ _2192_/Q _1115_/B _1120_/B VGND VGND VPWR VPWR _1115_/X sky130_fd_sc_hd__xnor3_1
X_1046_ _1010_/Y _1018_/Y _1644_/B _1014_/A VGND VGND VPWR VPWR _1047_/C sky130_fd_sc_hd__o211ai_1
XFILLER_21_223 VGND VGND VPWR VPWR sky130_fd_sc_hd__fill_1
XFILLER_21_234 VGND VGND VPWR VPWR sky130_fd_sc_hd__fill_1
XTAP_TAPCELL_ROW_31_284 VGND VPWR sky130_fd_sc_hd__tapvpwrvgnd_1
X_1948_ clkload1/A _1948_/D _1959_/DE VGND VGND VPWR VPWR _1948_/Q sky130_fd_sc_hd__edfxtp_1
X_1879_ _2106_/Q _1903_/Q _1887_/S VGND VGND VPWR VPWR _2106_/D sky130_fd_sc_hd__mux2_1
XTAP_TAPCELL_ROW_22_240 VGND VPWR sky130_fd_sc_hd__tapvpwrvgnd_1
XTAP_TAPCELL_ROW_45_354 VGND VPWR sky130_fd_sc_hd__tapvpwrvgnd_1
X_1802_ _1812_/A _1805_/S VGND VGND VPWR VPWR _1802_/Y sky130_fd_sc_hd__nand2_1
X_1733_ _1993_/Q _1747_/B VGND VGND VPWR VPWR _1733_/Y sky130_fd_sc_hd__nor2_1
Xhold249 _2160_/Q VGND VGND VPWR VPWR _2161_/D sky130_fd_sc_hd__dlygate4sd3_1
X_1664_ _2145_/Q _1664_/B _1664_/C VGND VGND VPWR VPWR _1961_/D sky130_fd_sc_hd__nor3_1
X_1595_ _1605_/A _1376_/X VGND VGND VPWR VPWR _1597_/C sky130_fd_sc_hd__nor2b_1
XFILLER_38_153 VGND VGND VPWR VPWR sky130_fd_sc_hd__fill_2
XFILLER_38_197 VGND VGND VPWR VPWR sky130_fd_sc_hd__fill_2
XTAP_TAPCELL_ROW_36_310 VGND VPWR sky130_fd_sc_hd__tapvpwrvgnd_1
X_2216_ _2223_/CLK _2216_/D VGND VGND VPWR VPWR _2216_/Q sky130_fd_sc_hd__dfxtp_1
Xload_slew152 fanout151/X VGND VGND VPWR VPWR _1459_/B sky130_fd_sc_hd__clkbuf_4
X_2147_ _2221_/CLK _2147_/D input1/X VGND VGND VPWR VPWR _2147_/Q sky130_fd_sc_hd__dfrtp_1
X_2078_ clkload2/A _2078_/D fanout59/A VGND VGND VPWR VPWR _2078_/Q sky130_fd_sc_hd__dfrtp_1
X_1029_ _1054_/B _1652_/C VGND VGND VPWR VPWR _1031_/A sky130_fd_sc_hd__nand2_1
XFILLER_39_77 VGND VGND VPWR VPWR sky130_fd_sc_hd__fill_1
XTAP_TAPCELL_ROW_59_424 VGND VPWR sky130_fd_sc_hd__tapvpwrvgnd_1
X_1380_ _2191_/Q _2175_/Q _1380_/S VGND VGND VPWR VPWR _1382_/B sky130_fd_sc_hd__mux2i_1
XFILLER_35_101 VGND VGND VPWR VPWR sky130_fd_sc_hd__decap_3
X_2001_ clkload5/A _2001_/D _2058_/SET_B VGND VGND VPWR VPWR _2001_/Q sky130_fd_sc_hd__dfstp_2
X_1716_ _1774_/D _2129_/Q _1840_/A _1840_/B VGND VGND VPWR VPWR wire96/A sky130_fd_sc_hd__nor4bb_4
X_1647_ _1652_/B fanout8/X _1659_/C1 VGND VGND VPWR VPWR _1647_/Y sky130_fd_sc_hd__o21ai_0
X_1578_ _1910_/Q _1617_/B _1577_/Y VGND VGND VPWR VPWR _1579_/C sky130_fd_sc_hd__a21oi_1
XFILLER_25_57 VGND VGND VPWR VPWR sky130_fd_sc_hd__decap_3
XFILLER_41_148 VGND VGND VPWR VPWR sky130_fd_sc_hd__decap_3
X_1501_ _1635_/A _1340_/X _1500_/Y VGND VGND VPWR VPWR _1501_/Y sky130_fd_sc_hd__a21oi_1
X_1432_ _1610_/A _2080_/Q _1444_/A3 _1431_/X VGND VGND VPWR VPWR _1947_/D sky130_fd_sc_hd__o31a_1
X_1363_ _1932_/Q _1950_/Q VGND VGND VPWR VPWR _1364_/C sky130_fd_sc_hd__xor2_1
XFILLER_48_270 VGND VGND VPWR VPWR sky130_fd_sc_hd__decap_4
X_1294_ _2176_/Q _1294_/B _1299_/B VGND VGND VPWR VPWR _1294_/X sky130_fd_sc_hd__xor3_1
XTAP_TAPCELL_ROW_61_441 VGND VPWR sky130_fd_sc_hd__tapvpwrvgnd_1
XFILLER_36_56 VGND VGND VPWR VPWR sky130_fd_sc_hd__decap_3
XTAP_TAPCELL_ROW_9_174 VGND VPWR sky130_fd_sc_hd__tapvpwrvgnd_1
XFILLER_37_229 VGND VGND VPWR VPWR sky130_fd_sc_hd__decap_3
X_1981_ _2161_/CLK _1981_/D load_slew79/X VGND VGND VPWR VPWR _1981_/Q sky130_fd_sc_hd__dfrtp_1
XFILLER_61_3 VGND VGND VPWR VPWR sky130_fd_sc_hd__fill_1
XFILLER_9_174 VGND VGND VPWR VPWR sky130_fd_sc_hd__fill_2
X_1415_ _1942_/Q _1935_/Q VGND VGND VPWR VPWR _1418_/A sky130_fd_sc_hd__nand2_1
X_1346_ _1346_/A _1346_/B _1346_/C VGND VGND VPWR VPWR _1346_/X sky130_fd_sc_hd__xnor3_1
Xwire33 wire33/A VGND VGND VPWR VPWR wire33/X sky130_fd_sc_hd__clkbuf_2
X_1277_ hold293/X _1282_/A2 _1276_/Y VGND VGND VPWR VPWR _2188_/D sky130_fd_sc_hd__a21o_1
XFILLER_22_69 VGND VGND VPWR VPWR sky130_fd_sc_hd__decap_12
Xfanout131 _1495_/B1 VGND VGND VPWR VPWR _1450_/A3 sky130_fd_sc_hd__clkdlybuf4s50_1
Xfanout142 _1773_/C VGND VGND VPWR VPWR _1858_/A sky130_fd_sc_hd__clkdlybuf4s50_1
Xfanout153 _1624_/B VGND VGND VPWR VPWR _1634_/B sky130_fd_sc_hd__clkdlybuf4s50_1
Xfanout164 _1440_/A1 VGND VGND VPWR VPWR _1625_/A sky130_fd_sc_hd__clkdlybuf4s50_1
Xfanout175 _1969_/Q VGND VGND VPWR VPWR _0969_/C sky130_fd_sc_hd__clkdlybuf4s50_1
Xfanout186 _1964_/Q VGND VGND VPWR VPWR _1824_/A0 sky130_fd_sc_hd__clkdlybuf4s50_1
Xfanout197 _1186_/A VGND VGND VPWR VPWR _1422_/S sky130_fd_sc_hd__clkdlybuf4s50_1
X_2180_ clkload3/A _2180_/D VGND VGND VPWR VPWR _2180_/Q sky130_fd_sc_hd__dfxtp_1
X_1200_ _2007_/Q _1300_/B1 _1199_/X VGND VGND VPWR VPWR _2200_/D sky130_fd_sc_hd__o21a_1
X_1131_ _1130_/X _2227_/Q _1416_/S VGND VGND VPWR VPWR _1131_/Y sky130_fd_sc_hd__mux2i_1
X_1062_ _1062_/A _1062_/B VGND VGND VPWR VPWR _1247_/B sky130_fd_sc_hd__nand2_1
X_1964_ _2161_/CLK _1964_/D fanout73/X VGND VGND VPWR VPWR _1964_/Q sky130_fd_sc_hd__dfrtp_1
X_1895_ clkload7/A _1895_/D VGND VGND VPWR VPWR _1895_/Q sky130_fd_sc_hd__dfxtp_1
XTAP_TAPCELL_ROW_3_147 VGND VPWR sky130_fd_sc_hd__tapvpwrvgnd_1
X_1329_ hold261/X _1329_/A2 _1328_/Y VGND VGND VPWR VPWR _2198_/D sky130_fd_sc_hd__a21o_1
XFILLER_33_35 VGND VGND VPWR VPWR sky130_fd_sc_hd__fill_1
XFILLER_33_57 VGND VGND VPWR VPWR sky130_fd_sc_hd__fill_2
XTAP_TAPCELL_ROW_17_216 VGND VPWR sky130_fd_sc_hd__tapvpwrvgnd_1
XFILLER_15_276 VGND VGND VPWR VPWR sky130_fd_sc_hd__decap_4
X_1680_ _1971_/Q _1992_/Q _1682_/S VGND VGND VPWR VPWR _1680_/Y sky130_fd_sc_hd__mux2i_1
XFILLER_24_3 VGND VGND VPWR VPWR sky130_fd_sc_hd__fill_1
X_2163_ _2166_/CLK _2163_/D fanout81/X VGND VGND VPWR VPWR _2163_/Q sky130_fd_sc_hd__dfrtp_1
X_1114_ _2209_/Q _2180_/Q VGND VGND VPWR VPWR _1120_/B sky130_fd_sc_hd__xor2_1
XFILLER_0_94 VGND VGND VPWR VPWR sky130_fd_sc_hd__decap_8
XTAP_TAPCELL_ROW_0_128 VGND VPWR sky130_fd_sc_hd__tapvpwrvgnd_1
X_2094_ clkload2/A _2094_/D fanout69/A VGND VGND VPWR VPWR _2094_/Q sky130_fd_sc_hd__dfrtp_1
X_1045_ _1055_/C _1048_/C _1045_/C VGND VGND VPWR VPWR _1045_/Y sky130_fd_sc_hd__nand3_1
XTAP_TAPCELL_ROW_31_285 VGND VPWR sky130_fd_sc_hd__tapvpwrvgnd_1
X_1947_ clkload1/A _1947_/D _1955_/DE VGND VGND VPWR VPWR _1947_/Q sky130_fd_sc_hd__edfxtp_1
X_1878_ _2105_/Q hold282/X _1887_/S VGND VGND VPWR VPWR _2105_/D sky130_fd_sc_hd__mux2_1
XFILLER_0_106 VGND VGND VPWR VPWR sky130_fd_sc_hd__decap_6
XFILLER_12_279 VGND VGND VPWR VPWR sky130_fd_sc_hd__decap_6
XTAP_TAPCELL_ROW_22_241 VGND VPWR sky130_fd_sc_hd__tapvpwrvgnd_1
XTAP_TAPCELL_ROW_54_399 VGND VPWR sky130_fd_sc_hd__tapvpwrvgnd_1
Xclkbuf_1_1__f_dclk clkbuf_0_dclk/X VGND VGND VPWR VPWR clkbuf_leaf_9_dclk/A sky130_fd_sc_hd__clkbuf_16
XTAP_TAPCELL_ROW_45_355 VGND VPWR sky130_fd_sc_hd__tapvpwrvgnd_1
X_1801_ _1801_/A _1840_/C _1821_/C VGND VGND VPWR VPWR wire33/A sky130_fd_sc_hd__nor3b_2
X_1732_ _1749_/B _1729_/Y _1730_/Y _1731_/Y VGND VGND VPWR VPWR _1992_/D sky130_fd_sc_hd__a31oi_1
X_1663_ wire52/X _2142_/Q _1410_/S VGND VGND VPWR VPWR _1664_/C sky130_fd_sc_hd__a21oi_1
XPHY_EDGE_ROW_7_Right_7 VGND VGND VPWR VPWR sky130_fd_sc_hd__decap_3
X_1594_ _1614_/A _1614_/B _1594_/C VGND VGND VPWR VPWR _1913_/D sky130_fd_sc_hd__nor3_1
XTAP_TAPCELL_ROW_36_311 VGND VPWR sky130_fd_sc_hd__tapvpwrvgnd_1
X_2215_ clkload3/A _2215_/D VGND VGND VPWR VPWR _2215_/Q sky130_fd_sc_hd__dfxtp_1
X_2146_ _2221_/CLK _2146_/D input1/X VGND VGND VPWR VPWR _2146_/Q sky130_fd_sc_hd__dfrtp_1
X_2077_ clkload2/A _2077_/D fanout61/X VGND VGND VPWR VPWR _2077_/Q sky130_fd_sc_hd__dfrtp_1
XFILLER_14_37 VGND VGND VPWR VPWR sky130_fd_sc_hd__fill_1
X_1028_ _1035_/A _1026_/Y _1049_/B VGND VGND VPWR VPWR _1054_/B sky130_fd_sc_hd__o21ai_0
XTAP_TAPCELL_ROW_59_425 VGND VPWR sky130_fd_sc_hd__tapvpwrvgnd_1
XFILLER_44_157 VGND VGND VPWR VPWR sky130_fd_sc_hd__decap_8
XTAP_TAPCELL_ROW_50_380 VGND VPWR sky130_fd_sc_hd__tapvpwrvgnd_1
XFILLER_4_253 VGND VGND VPWR VPWR sky130_fd_sc_hd__decap_12
X_2000_ _2208_/CLK _2000_/D wire86/X VGND VGND VPWR VPWR _2000_/Q sky130_fd_sc_hd__dfrtp_1
XFILLER_35_157 VGND VGND VPWR VPWR sky130_fd_sc_hd__decap_3
X_1715_ _1840_/B _1774_/D _2129_/Q _1840_/A VGND VGND VPWR VPWR wire98/A sky130_fd_sc_hd__nor4b_2
X_1646_ _1656_/A _1644_/B _1645_/Y VGND VGND VPWR VPWR _1646_/Y sky130_fd_sc_hd__a21oi_1
X_1577_ _1577_/A _1617_/B _1577_/C VGND VGND VPWR VPWR _1577_/Y sky130_fd_sc_hd__nor3_1
XFILLER_25_36 VGND VGND VPWR VPWR sky130_fd_sc_hd__decap_3
X_2129_ _2208_/CLK _2129_/D fanout88/X VGND VGND VPWR VPWR _2129_/Q sky130_fd_sc_hd__dfrtp_1
XFILLER_41_57 VGND VGND VPWR VPWR sky130_fd_sc_hd__fill_2
XFILLER_17_113 VGND VGND VPWR VPWR sky130_fd_sc_hd__fill_1
XFILLER_2_29 VGND VGND VPWR VPWR sky130_fd_sc_hd__decap_4
XFILLER_32_127 VGND VGND VPWR VPWR sky130_fd_sc_hd__fill_1
X_1500_ _1635_/A _1930_/Q _1556_/B1 VGND VGND VPWR VPWR _1500_/Y sky130_fd_sc_hd__o21ai_0
X_1431_ _1639_/A _1639_/B _1931_/Q _2064_/Q _1448_/A2 VGND VGND VPWR VPWR _1431_/X
+ sky130_fd_sc_hd__o32a_1
X_1362_ _2188_/Q _2172_/Q _1362_/S VGND VGND VPWR VPWR _1362_/Y sky130_fd_sc_hd__mux2i_1
X_1293_ _2193_/Q _2228_/Q VGND VGND VPWR VPWR _1299_/B sky130_fd_sc_hd__xor2_1
XFILLER_48_282 VGND VGND VPWR VPWR sky130_fd_sc_hd__decap_3
XTAP_TAPCELL_ROW_61_442 VGND VPWR sky130_fd_sc_hd__tapvpwrvgnd_1
X_1629_ _1629_/A _1629_/B _1629_/C VGND VGND VPWR VPWR _1920_/D sky130_fd_sc_hd__nor3_1
XFILLER_14_127 VGND VGND VPWR VPWR sky130_fd_sc_hd__decap_3
XTAP_TAPCELL_ROW_9_175 VGND VPWR sky130_fd_sc_hd__tapvpwrvgnd_1
X_1980_ _2161_/CLK _1980_/D wire75/X VGND VGND VPWR VPWR _1980_/Q sky130_fd_sc_hd__dfrtp_1
XFILLER_54_3 VGND VGND VPWR VPWR sky130_fd_sc_hd__fill_1
Xclkbuf_leaf_10_dclk clkbuf_leaf_9_dclk/A VGND VGND VPWR VPWR _2219_/CLK sky130_fd_sc_hd__clkbuf_16
X_1414_ _1495_/B1 _1412_/X _1413_/Y VGND VGND VPWR VPWR _1942_/D sky130_fd_sc_hd__a21oi_1
X_1345_ _1929_/Q _1947_/Q VGND VGND VPWR VPWR _1346_/C sky130_fd_sc_hd__xor2_1
X_1276_ _1368_/S _1274_/X _1275_/Y VGND VGND VPWR VPWR _1276_/Y sky130_fd_sc_hd__a21oi_1
Xwire12 wire12/A VGND VGND VPWR VPWR wire12/X sky130_fd_sc_hd__buf_2
XFILLER_22_48 VGND VGND VPWR VPWR sky130_fd_sc_hd__fill_1
Xfanout132 _1317_/C1 VGND VGND VPWR VPWR _1495_/B1 sky130_fd_sc_hd__clkdlybuf4s50_1
Xfanout143 _2163_/Q VGND VGND VPWR VPWR _1773_/C sky130_fd_sc_hd__clkdlybuf4s50_1
Xfanout154 _1629_/B VGND VGND VPWR VPWR _1624_/B sky130_fd_sc_hd__clkdlybuf4s50_1
Xfanout165 _1452_/A1 VGND VGND VPWR VPWR _1440_/A1 sky130_fd_sc_hd__clkdlybuf4s50_1
Xfanout176 _1969_/Q VGND VGND VPWR VPWR _1820_/A0 sky130_fd_sc_hd__clkdlybuf4s50_1
Xfanout187 _1718_/D VGND VGND VPWR VPWR _0968_/A sky130_fd_sc_hd__clkdlybuf4s50_1
Xfanout198 _1240_/A VGND VGND VPWR VPWR _1386_/S sky130_fd_sc_hd__clkdlybuf4s50_1
XFILLER_6_178 VGND VGND VPWR VPWR sky130_fd_sc_hd__decap_3
XPHY_EDGE_ROW_25_Left_87 VGND VGND VPWR VPWR sky130_fd_sc_hd__decap_3
X_1130_ _2195_/Q _1130_/B _1135_/B VGND VGND VPWR VPWR _1130_/X sky130_fd_sc_hd__xnor3_1
X_1061_ _1058_/Y _1060_/Y _1032_/Y _1052_/B VGND VGND VPWR VPWR _1062_/B sky130_fd_sc_hd__a31oi_1
X_1963_ _2166_/CLK _1963_/D fanout80/X VGND VGND VPWR VPWR _1963_/Q sky130_fd_sc_hd__dfrtp_1
X_1894_ clkload0/A _1894_/D VGND VGND VPWR VPWR _1894_/Q sky130_fd_sc_hd__dfxtp_1
XTAP_TAPCELL_ROW_3_148 VGND VPWR sky130_fd_sc_hd__tapvpwrvgnd_1
X_1328_ _1344_/S _1326_/X _1327_/Y VGND VGND VPWR VPWR _1328_/Y sky130_fd_sc_hd__a21oi_1
X_1259_ _1259_/A _1259_/B VGND VGND VPWR VPWR _1259_/X sky130_fd_sc_hd__and2_0
XFILLER_3_159 VGND VGND VPWR VPWR sky130_fd_sc_hd__fill_1
XFILLER_59_163 VGND VGND VPWR VPWR sky130_fd_sc_hd__fill_1
XTAP_TAPCELL_ROW_17_217 VGND VPWR sky130_fd_sc_hd__tapvpwrvgnd_1
XTAP_TAPCELL_ROW_0_129 VGND VPWR sky130_fd_sc_hd__tapvpwrvgnd_1
X_2162_ _2166_/CLK _2162_/D fanout76/X VGND VGND VPWR VPWR _2162_/Q sky130_fd_sc_hd__dfstp_2
X_2093_ clkload2/A _2093_/D fanout63/X VGND VGND VPWR VPWR _2093_/Q sky130_fd_sc_hd__dfrtp_1
X_1113_ _1459_/B _1604_/B hold264/X VGND VGND VPWR VPWR _1113_/Y sky130_fd_sc_hd__o21ai_0
X_1044_ _1044_/A _1055_/C _1923_/Q VGND VGND VPWR VPWR _1047_/B sky130_fd_sc_hd__nand3_1
XFILLER_21_258 VGND VGND VPWR VPWR sky130_fd_sc_hd__fill_1
XTAP_TAPCELL_ROW_31_286 VGND VPWR sky130_fd_sc_hd__tapvpwrvgnd_1
X_1946_ clkload8/A _1946_/D _1954_/DE VGND VGND VPWR VPWR _1946_/Q sky130_fd_sc_hd__edfxtp_1
X_1877_ _2104_/Q _1901_/Q _1882_/S VGND VGND VPWR VPWR _2104_/D sky130_fd_sc_hd__mux2_1
XFILLER_12_269 VGND VGND VPWR VPWR sky130_fd_sc_hd__decap_3
XTAP_TAPCELL_ROW_22_242 VGND VPWR sky130_fd_sc_hd__tapvpwrvgnd_1
XFILLER_47_133 VGND VGND VPWR VPWR sky130_fd_sc_hd__fill_1
XTAP_TAPCELL_ROW_45_356 VGND VPWR sky130_fd_sc_hd__tapvpwrvgnd_1
X_1800_ _0969_/C _2037_/Q wire12/X VGND VGND VPWR VPWR _2037_/D sky130_fd_sc_hd__mux2_1
X_1731_ _1992_/Q _1749_/B VGND VGND VPWR VPWR _1731_/Y sky130_fd_sc_hd__nor2_1
X_1662_ _1016_/A _0959_/Y _1640_/X _1661_/X VGND VGND VPWR VPWR _1928_/D sky130_fd_sc_hd__a31oi_1
X_2214_ _2230_/CLK _2214_/D VGND VGND VPWR VPWR _2214_/Q sky130_fd_sc_hd__dfxtp_1
Xclkbuf_leaf_8_dclk clkbuf_leaf_9_dclk/A VGND VGND VPWR VPWR _2224_/CLK sky130_fd_sc_hd__clkbuf_16
X_1593_ _1913_/Q _1632_/B _1592_/Y VGND VGND VPWR VPWR _1594_/C sky130_fd_sc_hd__a21oi_1
XPHY_EDGE_ROW_28_Left_90 VGND VGND VPWR VPWR sky130_fd_sc_hd__decap_3
XTAP_TAPCELL_ROW_36_312 VGND VPWR sky130_fd_sc_hd__tapvpwrvgnd_1
Xload_slew90 fanout89/X VGND VGND VPWR VPWR _2050_/SET_B sky130_fd_sc_hd__clkbuf_2
X_2145_ clkload7/A _2145_/D _2145_/SET_B VGND VGND VPWR VPWR _2145_/Q sky130_fd_sc_hd__dfstp_2
X_2076_ clkload5/A _2076_/D fanout59/A VGND VGND VPWR VPWR _2076_/Q sky130_fd_sc_hd__dfrtp_1
X_1027_ _1010_/Y _1018_/Y _1014_/A VGND VGND VPWR VPWR _1055_/A sky130_fd_sc_hd__o21ai_0
XFILLER_14_27 VGND VGND VPWR VPWR sky130_fd_sc_hd__fill_1
XPHY_EDGE_ROW_12_Left_74 VGND VGND VPWR VPWR sky130_fd_sc_hd__decap_3
X_1929_ clkload2/A _1929_/D _1955_/DE VGND VGND VPWR VPWR _1929_/Q sky130_fd_sc_hd__edfxtp_1
XFILLER_30_26 VGND VGND VPWR VPWR sky130_fd_sc_hd__fill_2
XFILLER_39_57 VGND VGND VPWR VPWR sky130_fd_sc_hd__decap_3
XTAP_TAPCELL_ROW_59_426 VGND VPWR sky130_fd_sc_hd__tapvpwrvgnd_1
XTAP_TAPCELL_ROW_50_381 VGND VPWR sky130_fd_sc_hd__tapvpwrvgnd_1
XFILLER_4_265 VGND VGND VPWR VPWR sky130_fd_sc_hd__decap_12
X_1714_ _0977_/A _1490_/S _1712_/Y _1713_/Y VGND VGND VPWR VPWR _1714_/Y sky130_fd_sc_hd__o22ai_1
X_1645_ _1656_/A _1644_/B _0981_/X _2141_/Q VGND VGND VPWR VPWR _1645_/Y sky130_fd_sc_hd__o22ai_1
X_1576_ _1932_/Q _1615_/A VGND VGND VPWR VPWR _1577_/A sky130_fd_sc_hd__nor2b_1
X_2128_ _2224_/CLK _2128_/D fanout80/X VGND VGND VPWR VPWR _2128_/Q sky130_fd_sc_hd__dfrtp_1
X_2059_ _2230_/CLK _2059_/D fanout66/X VGND VGND VPWR VPWR _2059_/Q sky130_fd_sc_hd__dfstp_2
X_1430_ _1635_/A _2079_/Q _1444_/A3 _1429_/X VGND VGND VPWR VPWR _1946_/D sky130_fd_sc_hd__o31a_1
XFILLER_48_250 VGND VGND VPWR VPWR sky130_fd_sc_hd__fill_2
X_1361_ _1933_/Q _1942_/Q VGND VGND VPWR VPWR _1364_/A sky130_fd_sc_hd__nand2_1
X_1292_ _2054_/Q _1297_/A2 _1291_/Y VGND VGND VPWR VPWR _2191_/D sky130_fd_sc_hd__a21o_1
XTAP_TAPCELL_ROW_61_443 VGND VPWR sky130_fd_sc_hd__tapvpwrvgnd_1
X_1628_ _1920_/Q _1627_/B _1627_/Y VGND VGND VPWR VPWR _1629_/C sky130_fd_sc_hd__a21oi_1
X_1559_ _1639_/A _1639_/B _1559_/C VGND VGND VPWR VPWR _1906_/D sky130_fd_sc_hd__nor3_1
XFILLER_14_139 VGND VGND VPWR VPWR sky130_fd_sc_hd__fill_1
XFILLER_22_194 VGND VGND VPWR VPWR sky130_fd_sc_hd__fill_2
XTAP_TAPCELL_ROW_9_176 VGND VPWR sky130_fd_sc_hd__tapvpwrvgnd_1
XFILLER_9_121 VGND VGND VPWR VPWR sky130_fd_sc_hd__fill_1
X_1413_ _2091_/Q _1456_/A2 _1456_/B1 _2075_/Q VGND VGND VPWR VPWR _1413_/Y sky130_fd_sc_hd__o22ai_1
XFILLER_3_73 VGND VGND VPWR VPWR sky130_fd_sc_hd__decap_3
Xwire35 wire35/A VGND VGND VPWR VPWR wire35/X sky130_fd_sc_hd__clkbuf_2
X_1344_ _2185_/Q _2169_/Q _1344_/S VGND VGND VPWR VPWR _1346_/B sky130_fd_sc_hd__mux2i_1
X_1275_ _1368_/S _2204_/Q _1285_/B1 VGND VGND VPWR VPWR _1275_/Y sky130_fd_sc_hd__o21ai_0
Xwire68 wire68/A VGND VGND VPWR VPWR wire68/X sky130_fd_sc_hd__buf_4
Xwire46 wire46/A VGND VGND VPWR VPWR wire46/X sky130_fd_sc_hd__clkdlybuf4s25_1
Xfanout122 _1324_/A2 VGND VGND VPWR VPWR _1661_/B1 sky130_fd_sc_hd__clkdlybuf4s50_1
Xfanout133 _1659_/C1 VGND VGND VPWR VPWR _1310_/B1 sky130_fd_sc_hd__clkdlybuf4s50_1
Xfanout144 _1624_/A VGND VGND VPWR VPWR _1634_/A sky130_fd_sc_hd__clkdlybuf4s50_1
Xfanout155 _1629_/B VGND VGND VPWR VPWR _1614_/B sky130_fd_sc_hd__clkdlybuf4s50_1
Xfanout166 _2138_/Q VGND VGND VPWR VPWR _1452_/A1 sky130_fd_sc_hd__clkdlybuf4s50_1
Xfanout177 _1968_/Q VGND VGND VPWR VPWR _0969_/D sky130_fd_sc_hd__clkdlybuf4s50_1
Xfanout188 _1963_/Q VGND VGND VPWR VPWR _1718_/D sky130_fd_sc_hd__clkdlybuf4s50_1
Xfanout199 _1380_/S VGND VGND VPWR VPWR _1240_/A sky130_fd_sc_hd__clkdlybuf4s50_1
XPHY_EDGE_ROW_29_Right_29 VGND VGND VPWR VPWR sky130_fd_sc_hd__decap_3
XPHY_EDGE_ROW_38_Right_38 VGND VGND VPWR VPWR sky130_fd_sc_hd__decap_3
XFILLER_12_93 VGND VGND VPWR VPWR sky130_fd_sc_hd__decap_12
XPHY_EDGE_ROW_0_Left_62 VGND VGND VPWR VPWR sky130_fd_sc_hd__decap_3
XPHY_EDGE_ROW_47_Right_47 VGND VGND VPWR VPWR sky130_fd_sc_hd__decap_3
X_1060_ _1060_/A _1060_/B _1060_/C VGND VGND VPWR VPWR _1060_/Y sky130_fd_sc_hd__nand3_1
XFILLER_33_278 VGND VGND VPWR VPWR sky130_fd_sc_hd__fill_2
XPHY_EDGE_ROW_56_Right_56 VGND VGND VPWR VPWR sky130_fd_sc_hd__decap_3
XTAP_TAPCELL_ROW_28_270 VGND VPWR sky130_fd_sc_hd__tapvpwrvgnd_1
X_1962_ _2166_/CLK _1962_/D fanout80/X VGND VGND VPWR VPWR _1962_/Q sky130_fd_sc_hd__dfrtp_1
X_1893_ clkload1/A _1893_/D VGND VGND VPWR VPWR _1893_/Q sky130_fd_sc_hd__dfxtp_1
X_1327_ _1344_/S _2214_/Q _1327_/B1 VGND VGND VPWR VPWR _1327_/Y sky130_fd_sc_hd__o21ai_0
X_1258_ _2169_/Q _1264_/B VGND VGND VPWR VPWR _1259_/A sky130_fd_sc_hd__xor2_1
X_1189_ _1392_/S _2181_/Q VGND VGND VPWR VPWR _1189_/Y sky130_fd_sc_hd__nor2b_1
XFILLER_58_56 VGND VGND VPWR VPWR sky130_fd_sc_hd__fill_1
XFILLER_59_131 VGND VGND VPWR VPWR sky130_fd_sc_hd__fill_1
XTAP_TAPCELL_ROW_17_218 VGND VPWR sky130_fd_sc_hd__tapvpwrvgnd_1
XFILLER_2_160 VGND VGND VPWR VPWR sky130_fd_sc_hd__fill_1
XFILLER_2_193 VGND VGND VPWR VPWR sky130_fd_sc_hd__decap_3
X_2230_ _2230_/CLK _2230_/D VGND VGND VPWR VPWR _2230_/Q sky130_fd_sc_hd__dfxtp_1
XFILLER_0_85 VGND VGND VPWR VPWR sky130_fd_sc_hd__decap_4
X_2161_ _2161_/CLK _2161_/D fanout76/X VGND VGND VPWR VPWR _2161_/Q sky130_fd_sc_hd__dfstp_2
X_2092_ clkload6/A _2092_/D fanout63/X VGND VGND VPWR VPWR _2092_/Q sky130_fd_sc_hd__dfrtp_1
X_1112_ hold262/X _1282_/A2 _1110_/Y _1111_/Y VGND VGND VPWR VPWR _2175_/D sky130_fd_sc_hd__o2bb2ai_1
X_1043_ _1652_/B _1652_/C VGND VGND VPWR VPWR _1644_/B sky130_fd_sc_hd__xor2_1
XFILLER_21_215 VGND VGND VPWR VPWR sky130_fd_sc_hd__fill_1
X_1945_ clkload2/A _1945_/D _1955_/DE VGND VGND VPWR VPWR _1945_/Q sky130_fd_sc_hd__edfxtp_1
XTAP_TAPCELL_ROW_31_287 VGND VPWR sky130_fd_sc_hd__tapvpwrvgnd_1
X_1876_ _2103_/Q hold263/X _1882_/S VGND VGND VPWR VPWR _2103_/D sky130_fd_sc_hd__mux2_1
XFILLER_28_59 VGND VGND VPWR VPWR sky130_fd_sc_hd__fill_1
XFILLER_12_237 VGND VGND VPWR VPWR sky130_fd_sc_hd__fill_1
XFILLER_20_281 VGND VGND VPWR VPWR sky130_fd_sc_hd__decap_4
XTAP_TAPCELL_ROW_22_243 VGND VPWR sky130_fd_sc_hd__tapvpwrvgnd_1
XFILLER_47_101 VGND VGND VPWR VPWR sky130_fd_sc_hd__fill_2
XFILLER_47_167 VGND VGND VPWR VPWR sky130_fd_sc_hd__fill_1
XTAP_TAPCELL_ROW_45_357 VGND VPWR sky130_fd_sc_hd__tapvpwrvgnd_1
XFILLER_11_281 VGND VGND VPWR VPWR sky130_fd_sc_hd__decap_4
XFILLER_7_241 VGND VGND VPWR VPWR sky130_fd_sc_hd__decap_8
X_1730_ _2104_/Q wire98/X wire42/X _2096_/Q VGND VGND VPWR VPWR _1730_/Y sky130_fd_sc_hd__a22oi_1
X_1661_ _1656_/A _1640_/X _1661_/B1 _1660_/Y VGND VGND VPWR VPWR _1661_/X sky130_fd_sc_hd__a211o_1
X_1592_ _1592_/A _1632_/B _1592_/C VGND VGND VPWR VPWR _1592_/Y sky130_fd_sc_hd__nor3_1
X_2213_ _2230_/CLK _2213_/D VGND VGND VPWR VPWR _2213_/Q sky130_fd_sc_hd__dfxtp_1
X_2144_ _2208_/CLK _2144_/D fanout82/X VGND VGND VPWR VPWR _2144_/Q sky130_fd_sc_hd__dfrtp_1
XFILLER_38_189 VGND VGND VPWR VPWR sky130_fd_sc_hd__fill_2
XFILLER_53_126 VGND VGND VPWR VPWR sky130_fd_sc_hd__fill_2
XTAP_TAPCELL_ROW_36_313 VGND VPWR sky130_fd_sc_hd__tapvpwrvgnd_1
X_1026_ _1055_/C _1048_/C _1013_/B _1013_/C VGND VGND VPWR VPWR _1026_/Y sky130_fd_sc_hd__a22oi_1
X_2075_ clkload6/A _2075_/D fanout57/X VGND VGND VPWR VPWR _2075_/Q sky130_fd_sc_hd__dfrtp_1
X_1928_ clkload4/A _1928_/D VGND VGND VPWR VPWR _1928_/Q sky130_fd_sc_hd__dfxtp_1
X_1859_ _1812_/A _2086_/Q _1866_/S VGND VGND VPWR VPWR _2086_/D sky130_fd_sc_hd__mux2_1
XTAP_TAPCELL_ROW_59_427 VGND VPWR sky130_fd_sc_hd__tapvpwrvgnd_1
XFILLER_4_244 VGND VGND VPWR VPWR sky130_fd_sc_hd__decap_8
XTAP_TAPCELL_ROW_50_382 VGND VPWR sky130_fd_sc_hd__tapvpwrvgnd_1
XFILLER_20_82 VGND VGND VPWR VPWR sky130_fd_sc_hd__fill_2
XFILLER_4_277 VGND VGND VPWR VPWR sky130_fd_sc_hd__decap_8
XFILLER_43_192 VGND VGND VPWR VPWR sky130_fd_sc_hd__fill_2
Xdigital_top_230 VGND VGND VPWR VPWR digital_top_230/HI duo_out[0] sky130_fd_sc_hd__conb_1
X_1713_ _1840_/A _1840_/B _1774_/D _2129_/Q _1858_/B VGND VGND VPWR VPWR _1713_/Y
+ sky130_fd_sc_hd__o41ai_1
X_1644_ _1656_/A _1644_/B VGND VGND VPWR VPWR _1644_/Y sky130_fd_sc_hd__nor2_1
X_1575_ _1620_/A _1352_/X VGND VGND VPWR VPWR _1577_/C sky130_fd_sc_hd__nor2b_1
X_2127_ _2166_/CLK _2127_/D fanout87/X VGND VGND VPWR VPWR _2127_/Q sky130_fd_sc_hd__dfrtp_1
XFILLER_34_170 VGND VGND VPWR VPWR sky130_fd_sc_hd__decap_3
X_1009_ _1016_/D _1009_/B VGND VGND VPWR VPWR _1013_/C sky130_fd_sc_hd__nand2_1
X_2058_ clkload5/A _2058_/D _2058_/SET_B VGND VGND VPWR VPWR _2058_/Q sky130_fd_sc_hd__dfstp_2
XFILLER_1_225 VGND VGND VPWR VPWR sky130_fd_sc_hd__fill_1
X_1360_ _0983_/B _1358_/X _1359_/Y VGND VGND VPWR VPWR _1933_/D sky130_fd_sc_hd__a21oi_1
X_1291_ _1386_/S _1289_/X _1290_/Y VGND VGND VPWR VPWR _1291_/Y sky130_fd_sc_hd__a21oi_1
X_1627_ _1627_/A _1627_/B _1627_/C VGND VGND VPWR VPWR _1627_/Y sky130_fd_sc_hd__nor3_1
X_1558_ _1906_/Q _1637_/B _1557_/Y VGND VGND VPWR VPWR _1559_/C sky130_fd_sc_hd__a21oi_1
X_1489_ _0969_/D _2136_/Q _1490_/S VGND VGND VPWR VPWR _2136_/D sky130_fd_sc_hd__mux2_1
XFILLER_7_3 VGND VGND VPWR VPWR sky130_fd_sc_hd__decap_3
XTAP_TAPCELL_ROW_9_177 VGND VPWR sky130_fd_sc_hd__tapvpwrvgnd_1
X_1412_ _1412_/A _1412_/B _1412_/C VGND VGND VPWR VPWR _1412_/X sky130_fd_sc_hd__xnor3_1
X_1343_ _1930_/Q _1939_/Q VGND VGND VPWR VPWR _1346_/A sky130_fd_sc_hd__nand2_1
X_1274_ _2172_/Q _1274_/B _1279_/B VGND VGND VPWR VPWR _1274_/X sky130_fd_sc_hd__xor3_1
X_0989_ _1016_/A _1440_/A1 _0966_/C _0987_/Y _2141_/Q VGND VGND VPWR VPWR _0989_/Y
+ sky130_fd_sc_hd__o311ai_0
Xfanout123 _1324_/A2 VGND VGND VPWR VPWR _1307_/A2 sky130_fd_sc_hd__clkdlybuf4s50_1
Xfanout134 _1317_/C1 VGND VGND VPWR VPWR _1659_/C1 sky130_fd_sc_hd__clkdlybuf4s50_1
Xfanout145 _1629_/A VGND VGND VPWR VPWR _1624_/A sky130_fd_sc_hd__clkdlybuf4s50_1
Xfanout156 _1664_/B VGND VGND VPWR VPWR _1629_/B sky130_fd_sc_hd__clkdlybuf4s50_1
Xfanout167 _1458_/A1 VGND VGND VPWR VPWR _1610_/A sky130_fd_sc_hd__clkdlybuf4s50_1
Xfanout178 _1968_/Q VGND VGND VPWR VPWR _1819_/A0 sky130_fd_sc_hd__clkdlybuf4s50_1
Xfanout189 _1962_/Q VGND VGND VPWR VPWR _1812_/A sky130_fd_sc_hd__clkdlybuf4s50_1
XFILLER_27_232 VGND VGND VPWR VPWR sky130_fd_sc_hd__fill_1
XFILLER_42_202 VGND VGND VPWR VPWR sky130_fd_sc_hd__fill_1
XTAP_TAPCELL_ROW_28_271 VGND VPWR sky130_fd_sc_hd__tapvpwrvgnd_1
X_1961_ clkload4/A _1961_/D VGND VGND VPWR VPWR _1961_/Q sky130_fd_sc_hd__dfxtp_1
X_1892_ clkload8/A _1892_/D VGND VGND VPWR VPWR _1892_/Q sky130_fd_sc_hd__dfxtp_1
X_1326_ _2183_/Q _1326_/B _1326_/C VGND VGND VPWR VPWR _1326_/X sky130_fd_sc_hd__xnor3_1
X_1257_ _2186_/Q _2221_/Q VGND VGND VPWR VPWR _1264_/B sky130_fd_sc_hd__xor2_1
X_1188_ _2035_/Q _1659_/C1 _1187_/X VGND VGND VPWR VPWR _2228_/D sky130_fd_sc_hd__o21a_1
Xmax_cap109 _1459_/Y VGND VGND VPWR VPWR fanout104/A sky130_fd_sc_hd__buf_1
X_2160_ _2161_/CLK _2160_/D fanout76/X VGND VGND VPWR VPWR _2160_/Q sky130_fd_sc_hd__dfstp_2
X_2091_ clkload6/A _2091_/D fanout63/X VGND VGND VPWR VPWR _2091_/Q sky130_fd_sc_hd__dfrtp_1
X_1111_ _1374_/S _1109_/X _1285_/B1 VGND VGND VPWR VPWR _1111_/Y sky130_fd_sc_hd__o21ai_0
X_1042_ _1023_/X _1015_/A _1042_/B1 VGND VGND VPWR VPWR _1052_/B sky130_fd_sc_hd__o21ai_0
XTAP_TAPCELL_ROW_31_288 VGND VPWR sky130_fd_sc_hd__tapvpwrvgnd_1
X_1944_ clkload2/A _1944_/D _1954_/DE VGND VGND VPWR VPWR _1944_/Q sky130_fd_sc_hd__edfxtp_1
X_1875_ _2102_/Q _1899_/Q _1884_/S VGND VGND VPWR VPWR _2102_/D sky130_fd_sc_hd__mux2_1
X_1309_ _2179_/Q _1309_/B _1315_/B VGND VGND VPWR VPWR _1309_/X sky130_fd_sc_hd__xor3_1
XFILLER_60_69 VGND VGND VPWR VPWR sky130_fd_sc_hd__fill_2
XFILLER_47_113 VGND VGND VPWR VPWR sky130_fd_sc_hd__fill_2
XFILLER_18_71 VGND VGND VPWR VPWR sky130_fd_sc_hd__decap_6
XTAP_TAPCELL_ROW_45_358 VGND VPWR sky130_fd_sc_hd__tapvpwrvgnd_1
XFILLER_50_80 VGND VGND VPWR VPWR sky130_fd_sc_hd__fill_1
X_1660_ fanout8/X _1658_/A _0958_/Y _1016_/A VGND VGND VPWR VPWR _1660_/Y sky130_fd_sc_hd__a31oi_1
X_1591_ _1935_/Q _1630_/A VGND VGND VPWR VPWR _1592_/A sky130_fd_sc_hd__nor2b_1
XFILLER_22_3 VGND VGND VPWR VPWR sky130_fd_sc_hd__fill_1
X_2212_ clkload3/A _2212_/D VGND VGND VPWR VPWR _2212_/Q sky130_fd_sc_hd__dfxtp_1
X_2143_ _2208_/CLK _2143_/D fanout82/X VGND VGND VPWR VPWR _2143_/Q sky130_fd_sc_hd__dfrtp_1
XPHY_EDGE_ROW_46_Left_108 VGND VGND VPWR VPWR sky130_fd_sc_hd__decap_3
X_1025_ _1025_/A _1025_/B _1025_/C _1048_/C VGND VGND VPWR VPWR _1049_/B sky130_fd_sc_hd__nand4_1
Xload_slew70 fanout69/X VGND VGND VPWR VPWR load_slew70/X sky130_fd_sc_hd__buf_4
X_2074_ clkload7/A _2074_/D load_slew58/X VGND VGND VPWR VPWR _2074_/Q sky130_fd_sc_hd__dfrtp_1
X_1927_ clkload3/A _1927_/D VGND VGND VPWR VPWR _1927_/Q sky130_fd_sc_hd__dfxtp_1
X_1858_ _1858_/A _1858_/B wire94/A _1858_/D VGND VGND VPWR VPWR _1861_/S sky130_fd_sc_hd__nand4_1
XPHY_EDGE_ROW_55_Left_117 VGND VGND VPWR VPWR sky130_fd_sc_hd__decap_3
XTAP_TAPCELL_ROW_59_428 VGND VPWR sky130_fd_sc_hd__tapvpwrvgnd_1
X_1789_ _2027_/Q _1818_/A0 _1789_/S VGND VGND VPWR VPWR _2027_/D sky130_fd_sc_hd__mux2_1
XFILLER_29_113 VGND VGND VPWR VPWR sky130_fd_sc_hd__decap_3
XTAP_TAPCELL_ROW_42_339 VGND VPWR sky130_fd_sc_hd__tapvpwrvgnd_1
XTAP_TAPCELL_ROW_50_383 VGND VPWR sky130_fd_sc_hd__tapvpwrvgnd_1
XANTENNA_1 _1562_/B VGND VGND VPWR VPWR sky130_fd_sc_hd__diode_2
Xdigital_top_220 VGND VGND VPWR VPWR digital_top_220/HI duio_oe[5] sky130_fd_sc_hd__conb_1
Xdigital_top_231 VGND VGND VPWR VPWR digital_top_231/HI duo_out[1] sky130_fd_sc_hd__conb_1
X_1712_ _2133_/Q _2132_/Q _1773_/C VGND VGND VPWR VPWR _1712_/Y sky130_fd_sc_hd__nand3b_1
X_1643_ _1652_/C fanout8/X _1659_/C1 _1642_/Y VGND VGND VPWR VPWR _1923_/D sky130_fd_sc_hd__o211a_1
X_1574_ _1639_/A _1639_/B _1574_/C VGND VGND VPWR VPWR _1909_/D sky130_fd_sc_hd__nor3_1
XTAP_TAPCELL_ROW_56_409 VGND VPWR sky130_fd_sc_hd__tapvpwrvgnd_1
Xclkbuf_leaf_13_dclk clkbuf_leaf_2_dclk/A VGND VGND VPWR VPWR clkload3/A sky130_fd_sc_hd__clkbuf_16
X_2126_ _2166_/CLK _2126_/D fanout87/X VGND VGND VPWR VPWR _2126_/Q sky130_fd_sc_hd__dfrtp_1
X_2057_ clkload5/A _2057_/D _2058_/SET_B VGND VGND VPWR VPWR _2057_/Q sky130_fd_sc_hd__dfrtp_1
XFILLER_41_27 VGND VGND VPWR VPWR sky130_fd_sc_hd__fill_2
X_1008_ _1022_/C _1008_/B VGND VGND VPWR VPWR _1009_/B sky130_fd_sc_hd__nand2b_1
XFILLER_1_248 VGND VGND VPWR VPWR sky130_fd_sc_hd__fill_1
XFILLER_1_259 VGND VGND VPWR VPWR sky130_fd_sc_hd__decap_6
XFILLER_57_274 VGND VGND VPWR VPWR sky130_fd_sc_hd__fill_1
XFILLER_31_71 VGND VGND VPWR VPWR sky130_fd_sc_hd__fill_1
XFILLER_0_281 VGND VGND VPWR VPWR sky130_fd_sc_hd__decap_4
XFILLER_48_241 VGND VGND VPWR VPWR sky130_fd_sc_hd__fill_1
X_1290_ _1386_/S _2207_/Q _1300_/B1 VGND VGND VPWR VPWR _1290_/Y sky130_fd_sc_hd__o21ai_0
XTAP_TAPCELL_ROW_61_434 VGND VPWR sky130_fd_sc_hd__tapvpwrvgnd_1
X_1626_ _1942_/Q _1625_/A VGND VGND VPWR VPWR _1627_/A sky130_fd_sc_hd__nor2b_1
XFILLER_39_252 VGND VGND VPWR VPWR sky130_fd_sc_hd__decap_12
X_1557_ _1610_/A _1424_/X _1556_/Y VGND VGND VPWR VPWR _1557_/Y sky130_fd_sc_hd__a21oi_1
X_1488_ _0969_/A _2135_/Q _1490_/S VGND VGND VPWR VPWR _2135_/D sky130_fd_sc_hd__mux2_1
X_2109_ clkload8/A _2109_/D load_slew70/X VGND VGND VPWR VPWR _2109_/Q sky130_fd_sc_hd__dfrtp_1
XTAP_TAPCELL_ROW_9_178 VGND VPWR sky130_fd_sc_hd__tapvpwrvgnd_1
XFILLER_13_185 VGND VGND VPWR VPWR sky130_fd_sc_hd__decap_3
XFILLER_13_196 VGND VGND VPWR VPWR sky130_fd_sc_hd__decap_3
XFILLER_42_70 VGND VGND VPWR VPWR sky130_fd_sc_hd__fill_2
XFILLER_9_167 VGND VGND VPWR VPWR sky130_fd_sc_hd__fill_1
XFILLER_3_31 VGND VGND VPWR VPWR sky130_fd_sc_hd__fill_1
X_1411_ _1940_/Q _1958_/Q VGND VGND VPWR VPWR _1412_/C sky130_fd_sc_hd__xor2_1
X_1342_ _1444_/A3 _1340_/X _1341_/Y VGND VGND VPWR VPWR _1930_/D sky130_fd_sc_hd__a21oi_1
X_1273_ _2189_/Q _2224_/Q VGND VGND VPWR VPWR _1279_/B sky130_fd_sc_hd__xor2_1
XFILLER_51_225 VGND VGND VPWR VPWR sky130_fd_sc_hd__fill_2
XFILLER_22_29 VGND VGND VPWR VPWR sky130_fd_sc_hd__fill_1
X_0988_ _1016_/A _1440_/A1 _0966_/C _0987_/Y _2141_/Q VGND VGND VPWR VPWR _0988_/X
+ sky130_fd_sc_hd__o311a_1
Xfanout102 _1885_/S VGND VGND VPWR VPWR _1465_/S sky130_fd_sc_hd__clkdlybuf4s50_1
Xfanout113 _1334_/Y VGND VGND VPWR VPWR _1456_/B1 sky130_fd_sc_hd__clkdlybuf4s50_1
X_1609_ _1609_/A _1609_/B _1609_/C VGND VGND VPWR VPWR _1916_/D sky130_fd_sc_hd__nor3_1
XTAP_TAPCELL_ROW_6_159 VGND VPWR sky130_fd_sc_hd__tapvpwrvgnd_1
Xfanout124 _0956_/X VGND VGND VPWR VPWR _1324_/A2 sky130_fd_sc_hd__clkdlybuf4s50_1
Xfanout135 _0955_/Y VGND VGND VPWR VPWR _1317_/C1 sky130_fd_sc_hd__clkdlybuf4s50_1
Xfanout146 _1629_/A VGND VGND VPWR VPWR _1614_/A sky130_fd_sc_hd__clkdlybuf4s50_1
Xfanout157 _1604_/B VGND VGND VPWR VPWR _1639_/B sky130_fd_sc_hd__clkdlybuf4s50_1
Xfanout168 _1600_/A VGND VGND VPWR VPWR _1635_/A sky130_fd_sc_hd__clkdlybuf4s50_1
Xfanout179 _1967_/Q VGND VGND VPWR VPWR _0969_/A sky130_fd_sc_hd__clkdlybuf4s50_1
XFILLER_18_277 VGND VGND VPWR VPWR sky130_fd_sc_hd__fill_1
XTAP_TAPCELL_ROW_28_272 VGND VPWR sky130_fd_sc_hd__tapvpwrvgnd_1
XFILLER_53_80 VGND VGND VPWR VPWR sky130_fd_sc_hd__fill_2
X_1960_ clkload5/A _1960_/D _1960_/DE VGND VGND VPWR VPWR _1960_/Q sky130_fd_sc_hd__edfxtp_1
X_1891_ clkload2/A _1891_/D VGND VGND VPWR VPWR _1891_/Q sky130_fd_sc_hd__dfxtp_1
X_1325_ _2218_/Q _2182_/Q VGND VGND VPWR VPWR _1326_/C sky130_fd_sc_hd__xnor2_1
X_1256_ hold275/X _1329_/A2 _1255_/Y VGND VGND VPWR VPWR _2184_/D sky130_fd_sc_hd__a21o_1
XFILLER_24_247 VGND VGND VPWR VPWR sky130_fd_sc_hd__decap_4
X_1187_ _1410_/S _2212_/Q _1186_/Y _1661_/B1 VGND VGND VPWR VPWR _1187_/X sky130_fd_sc_hd__a211o_1
XFILLER_15_214 VGND VGND VPWR VPWR sky130_fd_sc_hd__decap_4
XTAP_TAPCELL_ROW_2_140 VGND VPWR sky130_fd_sc_hd__tapvpwrvgnd_1
XFILLER_30_206 VGND VGND VPWR VPWR sky130_fd_sc_hd__fill_2
X_2090_ clkload0/A _2090_/D load_slew58/X VGND VGND VPWR VPWR _2090_/Q sky130_fd_sc_hd__dfrtp_1
X_1110_ _2223_/Q _1374_/S VGND VGND VPWR VPWR _1110_/Y sky130_fd_sc_hd__nor2b_1
X_1041_ _1014_/B _1014_/A _1023_/X _1042_/B1 VGND VGND VPWR VPWR _1041_/X sky130_fd_sc_hd__o31a_1
XFILLER_9_74 VGND VGND VPWR VPWR sky130_fd_sc_hd__decap_4
XFILLER_9_85 VGND VGND VPWR VPWR sky130_fd_sc_hd__decap_3
X_1943_ clkload5/A _1943_/D _1959_/DE VGND VGND VPWR VPWR _1943_/Q sky130_fd_sc_hd__edfxtp_1
X_1874_ _2101_/Q hold276/X _1882_/S VGND VGND VPWR VPWR _2101_/D sky130_fd_sc_hd__mux2_1
X_1308_ _2215_/Q _2196_/Q VGND VGND VPWR VPWR _1315_/B sky130_fd_sc_hd__xor2_1
X_1239_ _2020_/Q _1310_/B1 _1238_/X VGND VGND VPWR VPWR _2213_/D sky130_fd_sc_hd__o21a_1
XFILLER_7_221 VGND VGND VPWR VPWR sky130_fd_sc_hd__decap_3
X_1590_ _1630_/A _1370_/X VGND VGND VPWR VPWR _1592_/C sky130_fd_sc_hd__nor2b_1
X_1024_ _1658_/A _1024_/A2 _1022_/Y VGND VGND VPWR VPWR _1024_/Y sky130_fd_sc_hd__o21ai_0
X_2211_ clkload4/A _2211_/D VGND VGND VPWR VPWR _2211_/Q sky130_fd_sc_hd__dfxtp_1
Xload_slew60 fanout59/X VGND VGND VPWR VPWR load_slew60/X sky130_fd_sc_hd__clkbuf_4
X_2142_ clkload4/A _2142_/D VGND VGND VPWR VPWR _2142_/Q sky130_fd_sc_hd__dfxtp_1
X_2073_ clkload0/A _2073_/D load_slew60/X VGND VGND VPWR VPWR _2073_/Q sky130_fd_sc_hd__dfrtp_1
X_1926_ clkload4/A _1926_/D VGND VGND VPWR VPWR _1926_/Q sky130_fd_sc_hd__dfxtp_1
X_1857_ _0969_/C _2085_/Q _1857_/S VGND VGND VPWR VPWR _2085_/D sky130_fd_sc_hd__mux2_1
X_1788_ _2026_/Q _1817_/A0 _1789_/S VGND VGND VPWR VPWR _2026_/D sky130_fd_sc_hd__mux2_1
XANTENNA_2 _0969_/B VGND VGND VPWR VPWR sky130_fd_sc_hd__diode_2
Xdigital_top_221 VGND VGND VPWR VPWR digital_top_221/HI duio_oe[6] sky130_fd_sc_hd__conb_1
Xdigital_top_232 VGND VGND VPWR VPWR digital_top_232/HI duo_out[2] sky130_fd_sc_hd__conb_1
X_1711_ _2130_/Q _2131_/Q _1754_/B VGND VGND VPWR VPWR _1858_/B sky130_fd_sc_hd__and3b_1
X_1642_ _2141_/Q _0981_/X fanout8/X _1652_/C VGND VGND VPWR VPWR _1642_/Y sky130_fd_sc_hd__o211ai_1
X_1573_ _1909_/Q _1637_/B _1572_/Y VGND VGND VPWR VPWR _1574_/C sky130_fd_sc_hd__a21oi_1
XPHY_EDGE_ROW_16_Left_78 VGND VGND VPWR VPWR sky130_fd_sc_hd__decap_3
X_1007_ _1022_/C _1008_/B VGND VGND VPWR VPWR _1007_/Y sky130_fd_sc_hd__nor2b_1
X_2125_ clkload8/A _2125_/D load_slew70/X VGND VGND VPWR VPWR _2125_/Q sky130_fd_sc_hd__dfrtp_1
X_2056_ clkload5/A _2056_/D _2058_/SET_B VGND VGND VPWR VPWR _2056_/Q sky130_fd_sc_hd__dfstp_2
X_1909_ clkload1/A _1909_/D VGND VGND VPWR VPWR _1909_/Q sky130_fd_sc_hd__dfxtp_1
XFILLER_25_150 VGND VGND VPWR VPWR sky130_fd_sc_hd__fill_2
XTAP_TAPCELL_ROW_61_435 VGND VPWR sky130_fd_sc_hd__tapvpwrvgnd_1
X_1625_ _1625_/A _1412_/X VGND VGND VPWR VPWR _1627_/C sky130_fd_sc_hd__nor2b_1
X_1556_ _1610_/A _1944_/Q _1556_/B1 VGND VGND VPWR VPWR _1556_/Y sky130_fd_sc_hd__o21ai_0
X_1487_ _0969_/B _2134_/Q _1490_/S VGND VGND VPWR VPWR _2134_/D sky130_fd_sc_hd__mux2_1
X_2108_ clkload0/A _2108_/D fanout56/X VGND VGND VPWR VPWR _2108_/Q sky130_fd_sc_hd__dfrtp_1
X_2039_ _2223_/CLK _2039_/D _2023_/SET_B VGND VGND VPWR VPWR _2039_/Q sky130_fd_sc_hd__dfrtp_1
XFILLER_47_6 VGND VGND VPWR VPWR sky130_fd_sc_hd__fill_2
X_1410_ _2196_/Q _2180_/Q _1410_/S VGND VGND VPWR VPWR _1412_/B sky130_fd_sc_hd__mux2i_1
X_1341_ _2079_/Q _1448_/A2 _1448_/B1 _2063_/Q VGND VGND VPWR VPWR _1341_/Y sky130_fd_sc_hd__o22ai_1
X_1272_ _2050_/Q _1287_/A2 _1271_/Y VGND VGND VPWR VPWR _2187_/D sky130_fd_sc_hd__a21o_1
XFILLER_36_223 VGND VGND VPWR VPWR sky130_fd_sc_hd__fill_2
Xwire38 wire38/A VGND VGND VPWR VPWR wire38/X sky130_fd_sc_hd__buf_2
X_0987_ _1016_/A _1927_/Q _1656_/B _1656_/C _1440_/A1 VGND VGND VPWR VPWR _0987_/Y
+ sky130_fd_sc_hd__o41ai_1
Xfanout114 _1334_/Y VGND VGND VPWR VPWR _1448_/B1 sky130_fd_sc_hd__clkdlybuf4s50_1
Xfanout125 _1287_/A2 VGND VGND VPWR VPWR _1297_/A2 sky130_fd_sc_hd__clkdlybuf4s50_1
Xfanout136 _1442_/A3 VGND VGND VPWR VPWR _1444_/A3 sky130_fd_sc_hd__clkdlybuf4s50_1
Xfanout147 _2145_/Q VGND VGND VPWR VPWR _1629_/A sky130_fd_sc_hd__clkdlybuf4s50_1
X_1608_ _1916_/Q _1607_/B _1607_/Y VGND VGND VPWR VPWR _1609_/C sky130_fd_sc_hd__a21oi_1
X_1539_ _1639_/A _1639_/B _1539_/C VGND VGND VPWR VPWR _1901_/D sky130_fd_sc_hd__nor3_1
Xfanout158 _1604_/B VGND VGND VPWR VPWR _1609_/B sky130_fd_sc_hd__clkdlybuf4s50_1
Xfanout169 _1600_/A VGND VGND VPWR VPWR _1605_/A sky130_fd_sc_hd__clkdlybuf4s50_1
XPHY_EDGE_ROW_19_Left_81 VGND VGND VPWR VPWR sky130_fd_sc_hd__decap_3
XFILLER_10_145 VGND VGND VPWR VPWR sky130_fd_sc_hd__decap_8
XFILLER_10_178 VGND VGND VPWR VPWR sky130_fd_sc_hd__decap_3
XFILLER_12_74 VGND VGND VPWR VPWR sky130_fd_sc_hd__fill_1
XFILLER_6_138 VGND VGND VPWR VPWR sky130_fd_sc_hd__fill_2
XPHY_EDGE_ROW_16_Right_16 VGND VGND VPWR VPWR sky130_fd_sc_hd__decap_3
XTAP_TAPCELL_ROW_28_273 VGND VPWR sky130_fd_sc_hd__tapvpwrvgnd_1
XPHY_EDGE_ROW_25_Right_25 VGND VGND VPWR VPWR sky130_fd_sc_hd__decap_3
X_1890_ clkload4/A _1890_/D VGND VGND VPWR VPWR _1890_/Q sky130_fd_sc_hd__dfxtp_1
XFILLER_45_3 VGND VGND VPWR VPWR sky130_fd_sc_hd__fill_1
XTAP_TAPCELL_ROW_11_184 VGND VPWR sky130_fd_sc_hd__tapvpwrvgnd_1
XPHY_EDGE_ROW_34_Right_34 VGND VGND VPWR VPWR sky130_fd_sc_hd__decap_3
X_1324_ _2060_/Q _1324_/A2 _1323_/X VGND VGND VPWR VPWR _2197_/D sky130_fd_sc_hd__a21o_1
X_1255_ _1362_/S _1253_/X _1254_/Y VGND VGND VPWR VPWR _1255_/Y sky130_fd_sc_hd__a21oi_1
X_1186_ _1186_/A _2180_/Q VGND VGND VPWR VPWR _1186_/Y sky130_fd_sc_hd__nor2b_1
XPHY_EDGE_ROW_43_Right_43 VGND VGND VPWR VPWR sky130_fd_sc_hd__decap_3
XPHY_EDGE_ROW_52_Right_52 VGND VGND VPWR VPWR sky130_fd_sc_hd__decap_3
XTAP_TAPCELL_ROW_2_141 VGND VPWR sky130_fd_sc_hd__tapvpwrvgnd_1
XFILLER_23_281 VGND VGND VPWR VPWR sky130_fd_sc_hd__decap_4
XPHY_EDGE_ROW_4_Left_66 VGND VGND VPWR VPWR sky130_fd_sc_hd__decap_3
XPHY_EDGE_ROW_61_Right_61 VGND VGND VPWR VPWR sky130_fd_sc_hd__decap_3
XTAP_TAPCELL_ROW_25_254 VGND VPWR sky130_fd_sc_hd__tapvpwrvgnd_1
X_1040_ _1040_/A _1040_/B VGND VGND VPWR VPWR _1052_/A sky130_fd_sc_hd__nand2_1
XFILLER_0_55 VGND VGND VPWR VPWR sky130_fd_sc_hd__fill_1
XTAP_TAPCELL_ROW_16_210 VGND VPWR sky130_fd_sc_hd__tapvpwrvgnd_1
X_1942_ clkload6/A _1942_/D _1950_/DE VGND VGND VPWR VPWR _1942_/Q sky130_fd_sc_hd__edfxtp_1
X_1873_ _2100_/Q hold284/X _1885_/S VGND VGND VPWR VPWR _2100_/D sky130_fd_sc_hd__mux2_1
XTAP_TAPCELL_ROW_39_324 VGND VPWR sky130_fd_sc_hd__tapvpwrvgnd_1
X_1307_ hold292/X _1307_/A2 _1306_/Y VGND VGND VPWR VPWR _2194_/D sky130_fd_sc_hd__a21o_1
X_1238_ _1416_/S _2197_/Q _1237_/Y _1307_/A2 VGND VGND VPWR VPWR _1238_/X sky130_fd_sc_hd__a211o_1
X_1169_ _1216_/A _2174_/Q _1285_/B1 VGND VGND VPWR VPWR _1169_/Y sky130_fd_sc_hd__o21ai_0
XFILLER_12_218 VGND VGND VPWR VPWR sky130_fd_sc_hd__decap_3
X_2210_ clkload5/A _2210_/D VGND VGND VPWR VPWR _2210_/Q sky130_fd_sc_hd__dfxtp_1
Xload_slew103 _1465_/S VGND VGND VPWR VPWR _1887_/S sky130_fd_sc_hd__buf_4
X_1023_ _1658_/A _1024_/A2 _1022_/Y VGND VGND VPWR VPWR _1023_/X sky130_fd_sc_hd__o21a_1
Xload_slew72 fanout71/X VGND VGND VPWR VPWR fanout69/A sky130_fd_sc_hd__buf_2
X_2141_ clkload4/A _2141_/D VGND VGND VPWR VPWR _2141_/Q sky130_fd_sc_hd__dfxtp_1
X_2072_ clkload1/A _2072_/D load_slew60/X VGND VGND VPWR VPWR _2072_/Q sky130_fd_sc_hd__dfrtp_1
X_1925_ clkload4/A _1925_/D VGND VGND VPWR VPWR _1925_/Q sky130_fd_sc_hd__dfxtp_1
X_1856_ _0969_/D _2084_/Q _1856_/S VGND VGND VPWR VPWR _2084_/D sky130_fd_sc_hd__mux2_1
X_1787_ _2025_/Q _1816_/A0 _1789_/S VGND VGND VPWR VPWR _2025_/D sky130_fd_sc_hd__mux2_1
XPHY_EDGE_ROW_2_Right_2 VGND VGND VPWR VPWR sky130_fd_sc_hd__decap_3
Xdigital_top_222 VGND VGND VPWR VPWR digital_top_222/HI duio_oe[7] sky130_fd_sc_hd__conb_1
Xdigital_top_233 VGND VGND VPWR VPWR digital_top_233/HI duo_out[3] sky130_fd_sc_hd__conb_1
X_1710_ _2135_/Q _2134_/Q _2137_/Q _2136_/Q VGND VGND VPWR VPWR _1754_/B sky130_fd_sc_hd__nor4_1
X_1641_ _2141_/Q _0981_/X fanout8/X VGND VGND VPWR VPWR _1641_/Y sky130_fd_sc_hd__o21ai_0
X_1572_ _1572_/A _1637_/B _1572_/C VGND VGND VPWR VPWR _1572_/Y sky130_fd_sc_hd__nor3_1
X_2124_ clkload0/A _2124_/D fanout56/X VGND VGND VPWR VPWR _2124_/Q sky130_fd_sc_hd__dfrtp_1
XFILLER_19_181 VGND VGND VPWR VPWR sky130_fd_sc_hd__fill_2
XFILLER_25_19 VGND VGND VPWR VPWR sky130_fd_sc_hd__fill_1
X_1006_ _1017_/B _1006_/B _1654_/A VGND VGND VPWR VPWR _1013_/B sky130_fd_sc_hd__nand3_1
X_2055_ _2208_/CLK _2055_/D wire86/X VGND VGND VPWR VPWR _2055_/Q sky130_fd_sc_hd__dfstp_2
X_1908_ clkload8/A _1908_/D VGND VGND VPWR VPWR _1908_/Q sky130_fd_sc_hd__dfxtp_1
X_1839_ _0969_/C _2069_/Q wire29/A VGND VGND VPWR VPWR _2069_/D sky130_fd_sc_hd__mux2_1
XFILLER_40_165 VGND VGND VPWR VPWR sky130_fd_sc_hd__fill_2
XPHY_EDGE_ROW_33_Left_95 VGND VGND VPWR VPWR sky130_fd_sc_hd__decap_3
Xoutput5 _0991_/Y VGND VGND VPWR VPWR duio_out[2] sky130_fd_sc_hd__buf_2
XFILLER_31_187 VGND VGND VPWR VPWR sky130_fd_sc_hd__fill_1
XTAP_TAPCELL_ROW_61_436 VGND VPWR sky130_fd_sc_hd__tapvpwrvgnd_1
X_1624_ _1624_/A _1624_/B _1624_/C VGND VGND VPWR VPWR _1919_/D sky130_fd_sc_hd__nor3_1
X_1555_ _1614_/A _1614_/B _1555_/C VGND VGND VPWR VPWR _1905_/D sky130_fd_sc_hd__nor3_1
XFILLER_36_29 VGND VGND VPWR VPWR sky130_fd_sc_hd__fill_2
X_2107_ clkload6/A _2107_/D wire68/X VGND VGND VPWR VPWR _2107_/Q sky130_fd_sc_hd__dfrtp_1
X_1486_ _1816_/A0 _2133_/Q _1490_/S VGND VGND VPWR VPWR _2133_/D sky130_fd_sc_hd__mux2_1
X_2038_ clkload3/A _2038_/D fanout66/X VGND VGND VPWR VPWR _2038_/Q sky130_fd_sc_hd__dfrtp_1
X_1340_ _1340_/A _1340_/B _1340_/C VGND VGND VPWR VPWR _1340_/X sky130_fd_sc_hd__xnor3_1
XFILLER_36_213 VGND VGND VPWR VPWR sky130_fd_sc_hd__fill_1
X_1271_ _1210_/A _1269_/X _1270_/Y VGND VGND VPWR VPWR _1271_/Y sky130_fd_sc_hd__a21oi_1
Xwire39 wire39/A VGND VGND VPWR VPWR wire39/X sky130_fd_sc_hd__clkbuf_2
X_0986_ _2141_/Q _0966_/Y _1456_/A2 _0985_/X VGND VGND VPWR VPWR _2141_/D sky130_fd_sc_hd__a22o_1
Xfanout104 fanout104/A VGND VGND VPWR VPWR _1880_/S sky130_fd_sc_hd__clkdlybuf4s50_1
Xfanout126 _1287_/A2 VGND VGND VPWR VPWR _1329_/A2 sky130_fd_sc_hd__clkdlybuf4s50_1
Xfanout137 _0955_/Y VGND VGND VPWR VPWR _1442_/A3 sky130_fd_sc_hd__clkdlybuf4s50_1
Xfanout148 _1604_/A VGND VGND VPWR VPWR _1639_/A sky130_fd_sc_hd__clkdlybuf4s50_1
Xfanout159 _1664_/B VGND VGND VPWR VPWR _1604_/B sky130_fd_sc_hd__clkdlybuf4s50_1
X_1607_ _1607_/A _1607_/B _1607_/C VGND VGND VPWR VPWR _1607_/Y sky130_fd_sc_hd__nor3_1
X_1538_ _1901_/Q _1637_/B _1537_/Y VGND VGND VPWR VPWR _1539_/C sky130_fd_sc_hd__a21oi_1
X_1469_ _2124_/Q hold278/X _1887_/S VGND VGND VPWR VPWR _2124_/D sky130_fd_sc_hd__mux2_1
XFILLER_5_3 VGND VGND VPWR VPWR sky130_fd_sc_hd__fill_1
XFILLER_33_216 VGND VGND VPWR VPWR sky130_fd_sc_hd__decap_8
XTAP_TAPCELL_ROW_11_185 VGND VPWR sky130_fd_sc_hd__tapvpwrvgnd_1
XFILLER_38_3 VGND VGND VPWR VPWR sky130_fd_sc_hd__fill_1
X_1323_ _1331_/S _2213_/Q _1322_/Y _1321_/X _1659_/C1 VGND VGND VPWR VPWR _1323_/X
+ sky130_fd_sc_hd__o221a_1
XPHY_EDGE_ROW_20_Left_82 VGND VGND VPWR VPWR sky130_fd_sc_hd__decap_3
X_1254_ _1362_/S _2200_/Q _1327_/B1 VGND VGND VPWR VPWR _1254_/Y sky130_fd_sc_hd__o21ai_0
X_1185_ _2034_/Q _1661_/B1 _1183_/Y _1184_/Y VGND VGND VPWR VPWR _2227_/D sky130_fd_sc_hd__o2bb2ai_1
XTAP_TAPCELL_ROW_34_299 VGND VPWR sky130_fd_sc_hd__tapvpwrvgnd_1
X_0969_ _0969_/A _0969_/B _0969_/C _0969_/D VGND VGND VPWR VPWR _0969_/Y sky130_fd_sc_hd__nor4_1
XFILLER_59_113 VGND VGND VPWR VPWR sky130_fd_sc_hd__fill_1
XTAP_TAPCELL_ROW_25_255 VGND VPWR sky130_fd_sc_hd__tapvpwrvgnd_1
XTAP_TAPCELL_ROW_2_142 VGND VPWR sky130_fd_sc_hd__tapvpwrvgnd_1
XTAP_TAPCELL_ROW_48_369 VGND VPWR sky130_fd_sc_hd__tapvpwrvgnd_1
XFILLER_0_89 VGND VGND VPWR VPWR sky130_fd_sc_hd__fill_1
XTAP_TAPCELL_ROW_16_211 VGND VPWR sky130_fd_sc_hd__tapvpwrvgnd_1
X_1941_ clkload6/A _1941_/D _1958_/DE VGND VGND VPWR VPWR _1941_/Q sky130_fd_sc_hd__edfxtp_1
X_1872_ _2099_/Q hold291/X _1885_/S VGND VGND VPWR VPWR _2099_/D sky130_fd_sc_hd__mux2_1
XFILLER_56_105 VGND VGND VPWR VPWR sky130_fd_sc_hd__fill_2
XTAP_TAPCELL_ROW_39_325 VGND VPWR sky130_fd_sc_hd__tapvpwrvgnd_1
Xclkbuf_leaf_16_dclk clkbuf_leaf_2_dclk/A VGND VGND VPWR VPWR clkload6/A sky130_fd_sc_hd__clkbuf_16
X_1306_ _1416_/S _1304_/X _1305_/Y VGND VGND VPWR VPWR _1306_/Y sky130_fd_sc_hd__a21oi_1
X_1237_ _1416_/S _2229_/Q VGND VGND VPWR VPWR _1237_/Y sky130_fd_sc_hd__nor2b_1
X_1168_ _2206_/Q _1216_/A VGND VGND VPWR VPWR _1168_/Y sky130_fd_sc_hd__nor2b_1
X_1099_ _2206_/Q _2177_/Q VGND VGND VPWR VPWR _1104_/B sky130_fd_sc_hd__xor2_1
XTAP_TAPCELL_ROW_30_280 VGND VPWR sky130_fd_sc_hd__tapvpwrvgnd_1
XFILLER_18_85 VGND VGND VPWR VPWR sky130_fd_sc_hd__fill_1
XFILLER_11_241 VGND VGND VPWR VPWR sky130_fd_sc_hd__decap_12
XTAP_TAPCELL_ROW_53_394 VGND VPWR sky130_fd_sc_hd__tapvpwrvgnd_1
XFILLER_7_234 VGND VGND VPWR VPWR sky130_fd_sc_hd__fill_2
Xwire110 _1362_/Y VGND VGND VPWR VPWR _1364_/B sky130_fd_sc_hd__clkbuf_2
X_2140_ clkload4/A _2140_/D VGND VGND VPWR VPWR _2140_/Q sky130_fd_sc_hd__dfxtp_1
X_1022_ _1658_/A _1022_/B _1022_/C _1928_/Q VGND VGND VPWR VPWR _1022_/Y sky130_fd_sc_hd__nand4_1
Xload_slew84 fanout83/X VGND VGND VPWR VPWR _2023_/SET_B sky130_fd_sc_hd__buf_2
Xload_slew62 fanout61/X VGND VGND VPWR VPWR fanout59/A sky130_fd_sc_hd__buf_4
X_2071_ clkload9/A _2071_/D load_slew70/X VGND VGND VPWR VPWR _2071_/Q sky130_fd_sc_hd__dfrtp_1
XTAP_TAPCELL_ROW_44_350 VGND VPWR sky130_fd_sc_hd__tapvpwrvgnd_1
X_1924_ clkload4/A _1924_/D VGND VGND VPWR VPWR _1924_/Q sky130_fd_sc_hd__dfxtp_1
X_1855_ _0969_/A _2083_/Q _1856_/S VGND VGND VPWR VPWR _2083_/D sky130_fd_sc_hd__mux2_1
Xfanout6 _1714_/Y VGND VGND VPWR VPWR _1747_/B sky130_fd_sc_hd__clkdlybuf4s50_1
X_1786_ _2024_/Q _1824_/A0 wire35/X VGND VGND VPWR VPWR _2024_/D sky130_fd_sc_hd__mux2_1
XFILLER_29_149 VGND VGND VPWR VPWR sky130_fd_sc_hd__decap_3
XFILLER_4_204 VGND VGND VPWR VPWR sky130_fd_sc_hd__fill_2
XFILLER_4_226 VGND VGND VPWR VPWR sky130_fd_sc_hd__fill_1
XPHY_EDGE_ROW_42_Left_104 VGND VGND VPWR VPWR sky130_fd_sc_hd__decap_3
XFILLER_28_193 VGND VGND VPWR VPWR sky130_fd_sc_hd__decap_3
XTAP_TAPCELL_ROW_58_420 VGND VPWR sky130_fd_sc_hd__tapvpwrvgnd_1
XPHY_EDGE_ROW_51_Left_113 VGND VGND VPWR VPWR sky130_fd_sc_hd__decap_3
Xdigital_top_223 VGND VGND VPWR VPWR digital_top_223/HI duio_out[0] sky130_fd_sc_hd__conb_1
Xdigital_top_234 VGND VGND VPWR VPWR digital_top_234/HI duo_out[4] sky130_fd_sc_hd__conb_1
XFILLER_3_270 VGND VGND VPWR VPWR sky130_fd_sc_hd__fill_1
XFILLER_3_281 VGND VGND VPWR VPWR sky130_fd_sc_hd__decap_4
XPHY_EDGE_ROW_60_Left_122 VGND VGND VPWR VPWR sky130_fd_sc_hd__decap_3
X_1640_ _2141_/Q _2142_/Q _1627_/B VGND VGND VPWR VPWR _1640_/X sky130_fd_sc_hd__o21a_1
X_1571_ _1931_/Q _1610_/A VGND VGND VPWR VPWR _1572_/A sky130_fd_sc_hd__nor2b_1
X_2123_ clkload6/A _2123_/D wire68/X VGND VGND VPWR VPWR _2123_/Q sky130_fd_sc_hd__dfrtp_1
XFILLER_34_141 VGND VGND VPWR VPWR sky130_fd_sc_hd__fill_2
X_1005_ _1654_/A _0997_/Y _1060_/B VGND VGND VPWR VPWR _1025_/A sky130_fd_sc_hd__o21ai_1
X_2054_ _2230_/CLK _2054_/D fanout83/X VGND VGND VPWR VPWR _2054_/Q sky130_fd_sc_hd__dfrtp_1
X_1907_ _2208_/CLK _1907_/D VGND VGND VPWR VPWR _1907_/Q sky130_fd_sc_hd__dfxtp_1
X_1838_ _0969_/D _2068_/Q wire29/X VGND VGND VPWR VPWR _2068_/D sky130_fd_sc_hd__mux2_1
XFILLER_1_207 VGND VGND VPWR VPWR sky130_fd_sc_hd__fill_1
X_1769_ _1817_/A0 _2010_/Q wire38/X VGND VGND VPWR VPWR _2010_/D sky130_fd_sc_hd__mux2_1
XFILLER_15_97 VGND VGND VPWR VPWR sky130_fd_sc_hd__decap_4
XFILLER_0_251 VGND VGND VPWR VPWR sky130_fd_sc_hd__fill_1
XFILLER_31_133 VGND VGND VPWR VPWR sky130_fd_sc_hd__fill_1
XTAP_TAPCELL_ROW_61_437 VGND VPWR sky130_fd_sc_hd__tapvpwrvgnd_1
XFILLER_31_177 VGND VGND VPWR VPWR sky130_fd_sc_hd__fill_2
X_1623_ _1919_/Q _1627_/B _1622_/Y VGND VGND VPWR VPWR _1624_/C sky130_fd_sc_hd__a21oi_1
X_1554_ _1905_/Q _1632_/B _1553_/Y VGND VGND VPWR VPWR _1555_/C sky130_fd_sc_hd__a21oi_1
X_1485_ _1721_/A _2132_/Q _1490_/S VGND VGND VPWR VPWR _2132_/D sky130_fd_sc_hd__mux2_1
.ends
